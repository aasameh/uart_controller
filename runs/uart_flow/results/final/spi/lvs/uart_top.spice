* NGSPICE file created from uart_top.ext - technology: sky130A

* Black-box entry subcircuit for sky130_fd_sc_hd__fill_2 abstract view
.subckt sky130_fd_sc_hd__fill_2 VGND VNB VPB VPWR
.ends

* Black-box entry subcircuit for sky130_fd_sc_hd__tapvpwrvgnd_1 abstract view
.subckt sky130_fd_sc_hd__tapvpwrvgnd_1 VGND VPWR
.ends

* Black-box entry subcircuit for sky130_fd_sc_hd__nand2_1 abstract view
.subckt sky130_fd_sc_hd__nand2_1 A B VGND VNB VPB VPWR Y
.ends

* Black-box entry subcircuit for sky130_fd_sc_hd__and4b_4 abstract view
.subckt sky130_fd_sc_hd__and4b_4 A_N B C D VGND VNB VPB VPWR X
.ends

* Black-box entry subcircuit for sky130_ef_sc_hd__decap_12 abstract view
.subckt sky130_ef_sc_hd__decap_12 VPWR VGND VPB VNB
.ends

* Black-box entry subcircuit for sky130_fd_sc_hd__fill_1 abstract view
.subckt sky130_fd_sc_hd__fill_1 VGND VNB VPB VPWR
.ends

* Black-box entry subcircuit for sky130_fd_sc_hd__dfrtp_4 abstract view
.subckt sky130_fd_sc_hd__dfrtp_4 CLK D RESET_B VGND VNB VPB VPWR Q
.ends

* Black-box entry subcircuit for sky130_fd_sc_hd__decap_4 abstract view
.subckt sky130_fd_sc_hd__decap_4 VGND VNB VPB VPWR
.ends

* Black-box entry subcircuit for sky130_fd_sc_hd__decap_6 abstract view
.subckt sky130_fd_sc_hd__decap_6 VGND VNB VPB VPWR
.ends

* Black-box entry subcircuit for sky130_fd_sc_hd__nor3_1 abstract view
.subckt sky130_fd_sc_hd__nor3_1 A B C VGND VNB VPB VPWR Y
.ends

* Black-box entry subcircuit for sky130_fd_sc_hd__decap_8 abstract view
.subckt sky130_fd_sc_hd__decap_8 VGND VNB VPB VPWR
.ends

* Black-box entry subcircuit for sky130_fd_sc_hd__edfxtp_1 abstract view
.subckt sky130_fd_sc_hd__edfxtp_1 CLK D DE VGND VNB VPB VPWR Q
.ends

* Black-box entry subcircuit for sky130_fd_sc_hd__a221o_1 abstract view
.subckt sky130_fd_sc_hd__a221o_1 A1 A2 B1 B2 C1 VGND VNB VPB VPWR X
.ends

* Black-box entry subcircuit for sky130_fd_sc_hd__nand4_1 abstract view
.subckt sky130_fd_sc_hd__nand4_1 A B C D VGND VNB VPB VPWR Y
.ends

* Black-box entry subcircuit for sky130_fd_sc_hd__xnor2_1 abstract view
.subckt sky130_fd_sc_hd__xnor2_1 A B VGND VNB VPB VPWR Y
.ends

* Black-box entry subcircuit for sky130_fd_sc_hd__clkbuf_2 abstract view
.subckt sky130_fd_sc_hd__clkbuf_2 A VGND VNB VPB VPWR X
.ends

* Black-box entry subcircuit for sky130_fd_sc_hd__o2111a_1 abstract view
.subckt sky130_fd_sc_hd__o2111a_1 A1 A2 B1 C1 D1 VGND VNB VPB VPWR X
.ends

* Black-box entry subcircuit for sky130_fd_sc_hd__clkbuf_4 abstract view
.subckt sky130_fd_sc_hd__clkbuf_4 A VGND VNB VPB VPWR X
.ends

* Black-box entry subcircuit for sky130_fd_sc_hd__buf_4 abstract view
.subckt sky130_fd_sc_hd__buf_4 A VGND VNB VPB VPWR X
.ends

* Black-box entry subcircuit for sky130_fd_sc_hd__decap_3 abstract view
.subckt sky130_fd_sc_hd__decap_3 VGND VNB VPB VPWR
.ends

* Black-box entry subcircuit for sky130_fd_sc_hd__a222oi_1 abstract view
.subckt sky130_fd_sc_hd__a222oi_1 A1 A2 B1 B2 C1 C2 VGND VNB VPB VPWR Y
.ends

* Black-box entry subcircuit for sky130_fd_sc_hd__o22ai_1 abstract view
.subckt sky130_fd_sc_hd__o22ai_1 A1 A2 B1 B2 VGND VNB VPB VPWR Y
.ends

* Black-box entry subcircuit for sky130_fd_sc_hd__clkbuf_1 abstract view
.subckt sky130_fd_sc_hd__clkbuf_1 A VGND VNB VPB VPWR X
.ends

* Black-box entry subcircuit for sky130_fd_sc_hd__nor2_1 abstract view
.subckt sky130_fd_sc_hd__nor2_1 A B VGND VNB VPB VPWR Y
.ends

* Black-box entry subcircuit for sky130_fd_sc_hd__nand2_4 abstract view
.subckt sky130_fd_sc_hd__nand2_4 A B VGND VNB VPB VPWR Y
.ends

* Black-box entry subcircuit for sky130_fd_sc_hd__nor4b_1 abstract view
.subckt sky130_fd_sc_hd__nor4b_1 A B C D_N VGND VNB VPB VPWR Y
.ends

* Black-box entry subcircuit for sky130_fd_sc_hd__mux2_1 abstract view
.subckt sky130_fd_sc_hd__mux2_1 A0 A1 S VGND VNB VPB VPWR X
.ends

* Black-box entry subcircuit for sky130_fd_sc_hd__nor3_2 abstract view
.subckt sky130_fd_sc_hd__nor3_2 A B C VGND VNB VPB VPWR Y
.ends

* Black-box entry subcircuit for sky130_fd_sc_hd__dfrtp_1 abstract view
.subckt sky130_fd_sc_hd__dfrtp_1 CLK D RESET_B VGND VNB VPB VPWR Q
.ends

* Black-box entry subcircuit for sky130_fd_sc_hd__o21a_1 abstract view
.subckt sky130_fd_sc_hd__o21a_1 A1 A2 B1 VGND VNB VPB VPWR X
.ends

* Black-box entry subcircuit for sky130_fd_sc_hd__dlygate4sd3_1 abstract view
.subckt sky130_fd_sc_hd__dlygate4sd3_1 A VGND VNB VPB VPWR X
.ends

* Black-box entry subcircuit for sky130_fd_sc_hd__buf_1 abstract view
.subckt sky130_fd_sc_hd__buf_1 A VGND VNB VPB VPWR X
.ends

* Black-box entry subcircuit for sky130_fd_sc_hd__diode_2 abstract view
.subckt sky130_fd_sc_hd__diode_2 DIODE VGND VNB VPB VPWR
.ends

* Black-box entry subcircuit for sky130_fd_sc_hd__a22o_1 abstract view
.subckt sky130_fd_sc_hd__a22o_1 A1 A2 B1 B2 VGND VNB VPB VPWR X
.ends

* Black-box entry subcircuit for sky130_fd_sc_hd__dfstp_2 abstract view
.subckt sky130_fd_sc_hd__dfstp_2 CLK D SET_B VGND VNB VPB VPWR Q
.ends

* Black-box entry subcircuit for sky130_fd_sc_hd__o21ai_2 abstract view
.subckt sky130_fd_sc_hd__o21ai_2 A1 A2 B1 VGND VNB VPB VPWR Y
.ends

* Black-box entry subcircuit for sky130_fd_sc_hd__lpflow_isobufsrc_1 abstract view
.subckt sky130_fd_sc_hd__lpflow_isobufsrc_1 A SLEEP VGND VNB VPB VPWR X
.ends

* Black-box entry subcircuit for sky130_fd_sc_hd__o21ai_0 abstract view
.subckt sky130_fd_sc_hd__o21ai_0 A1 A2 B1 VGND VNB VPB VPWR Y
.ends

* Black-box entry subcircuit for sky130_fd_sc_hd__a22oi_1 abstract view
.subckt sky130_fd_sc_hd__a22oi_1 A1 A2 B1 B2 VGND VNB VPB VPWR Y
.ends

* Black-box entry subcircuit for sky130_fd_sc_hd__a21oi_1 abstract view
.subckt sky130_fd_sc_hd__a21oi_1 A1 A2 B1 VGND VNB VPB VPWR Y
.ends

* Black-box entry subcircuit for sky130_fd_sc_hd__nand3_1 abstract view
.subckt sky130_fd_sc_hd__nand3_1 A B C VGND VNB VPB VPWR Y
.ends

* Black-box entry subcircuit for sky130_fd_sc_hd__and2_1 abstract view
.subckt sky130_fd_sc_hd__and2_1 A B VGND VNB VPB VPWR X
.ends

* Black-box entry subcircuit for sky130_fd_sc_hd__nand2b_1 abstract view
.subckt sky130_fd_sc_hd__nand2b_1 A_N B VGND VNB VPB VPWR Y
.ends

* Black-box entry subcircuit for sky130_fd_sc_hd__a221oi_2 abstract view
.subckt sky130_fd_sc_hd__a221oi_2 A1 A2 B1 B2 C1 VGND VNB VPB VPWR Y
.ends

* Black-box entry subcircuit for sky130_fd_sc_hd__nor3b_2 abstract view
.subckt sky130_fd_sc_hd__nor3b_2 A B C_N VGND VNB VPB VPWR Y
.ends

* Black-box entry subcircuit for sky130_fd_sc_hd__nand2_2 abstract view
.subckt sky130_fd_sc_hd__nand2_2 A B VGND VNB VPB VPWR Y
.ends

* Black-box entry subcircuit for sky130_fd_sc_hd__and3_1 abstract view
.subckt sky130_fd_sc_hd__and3_1 A B C VGND VNB VPB VPWR X
.ends

* Black-box entry subcircuit for sky130_fd_sc_hd__nand3_4 abstract view
.subckt sky130_fd_sc_hd__nand3_4 A B C VGND VNB VPB VPWR Y
.ends

* Black-box entry subcircuit for sky130_fd_sc_hd__o21a_2 abstract view
.subckt sky130_fd_sc_hd__o21a_2 A1 A2 B1 VGND VNB VPB VPWR X
.ends

* Black-box entry subcircuit for sky130_fd_sc_hd__nand3_2 abstract view
.subckt sky130_fd_sc_hd__nand3_2 A B C VGND VNB VPB VPWR Y
.ends

* Black-box entry subcircuit for sky130_fd_sc_hd__buf_2 abstract view
.subckt sky130_fd_sc_hd__buf_2 A VGND VNB VPB VPWR X
.ends

* Black-box entry subcircuit for sky130_fd_sc_hd__nor4b_2 abstract view
.subckt sky130_fd_sc_hd__nor4b_2 A B C D_N VGND VNB VPB VPWR Y
.ends

* Black-box entry subcircuit for sky130_fd_sc_hd__dfrtp_2 abstract view
.subckt sky130_fd_sc_hd__dfrtp_2 CLK D RESET_B VGND VNB VPB VPWR Q
.ends

* Black-box entry subcircuit for sky130_fd_sc_hd__and3b_1 abstract view
.subckt sky130_fd_sc_hd__and3b_1 A_N B C VGND VNB VPB VPWR X
.ends

* Black-box entry subcircuit for sky130_fd_sc_hd__o31ai_1 abstract view
.subckt sky130_fd_sc_hd__o31ai_1 A1 A2 A3 B1 VGND VNB VPB VPWR Y
.ends

* Black-box entry subcircuit for sky130_fd_sc_hd__nor2_2 abstract view
.subckt sky130_fd_sc_hd__nor2_2 A B VGND VNB VPB VPWR Y
.ends

* Black-box entry subcircuit for sky130_fd_sc_hd__nor4b_4 abstract view
.subckt sky130_fd_sc_hd__nor4b_4 A B C D_N VGND VNB VPB VPWR Y
.ends

* Black-box entry subcircuit for sky130_fd_sc_hd__mux2i_4 abstract view
.subckt sky130_fd_sc_hd__mux2i_4 A0 A1 S VGND VNB VPB VPWR Y
.ends

* Black-box entry subcircuit for sky130_fd_sc_hd__or4_1 abstract view
.subckt sky130_fd_sc_hd__or4_1 A B C D VGND VNB VPB VPWR X
.ends

* Black-box entry subcircuit for sky130_fd_sc_hd__and4_1 abstract view
.subckt sky130_fd_sc_hd__and4_1 A B C D VGND VNB VPB VPWR X
.ends

* Black-box entry subcircuit for sky130_fd_sc_hd__xor2_1 abstract view
.subckt sky130_fd_sc_hd__xor2_1 A B VGND VNB VPB VPWR X
.ends

* Black-box entry subcircuit for sky130_fd_sc_hd__nor4bb_4 abstract view
.subckt sky130_fd_sc_hd__nor4bb_4 A B C_N D_N VGND VNB VPB VPWR Y
.ends

* Black-box entry subcircuit for sky130_fd_sc_hd__a221oi_1 abstract view
.subckt sky130_fd_sc_hd__a221oi_1 A1 A2 B1 B2 C1 VGND VNB VPB VPWR Y
.ends

* Black-box entry subcircuit for sky130_fd_sc_hd__clkbuf_16 abstract view
.subckt sky130_fd_sc_hd__clkbuf_16 A VGND VNB VPB VPWR X
.ends

* Black-box entry subcircuit for sky130_fd_sc_hd__a21o_1 abstract view
.subckt sky130_fd_sc_hd__a21o_1 A1 A2 B1 VGND VNB VPB VPWR X
.ends

* Black-box entry subcircuit for sky130_fd_sc_hd__nor4bb_1 abstract view
.subckt sky130_fd_sc_hd__nor4bb_1 A B C_N D_N VGND VNB VPB VPWR Y
.ends

* Black-box entry subcircuit for sky130_fd_sc_hd__a21boi_0 abstract view
.subckt sky130_fd_sc_hd__a21boi_0 A1 A2 B1_N VGND VNB VPB VPWR Y
.ends

* Black-box entry subcircuit for sky130_fd_sc_hd__nor4_1 abstract view
.subckt sky130_fd_sc_hd__nor4_1 A B C D VGND VNB VPB VPWR Y
.ends

* Black-box entry subcircuit for sky130_fd_sc_hd__o2bb2ai_1 abstract view
.subckt sky130_fd_sc_hd__o2bb2ai_1 A1_N A2_N B1 B2 VGND VNB VPB VPWR Y
.ends

* Black-box entry subcircuit for sky130_fd_sc_hd__nand3b_1 abstract view
.subckt sky130_fd_sc_hd__nand3b_1 A_N B C VGND VNB VPB VPWR Y
.ends

* Black-box entry subcircuit for sky130_fd_sc_hd__o41a_1 abstract view
.subckt sky130_fd_sc_hd__o41a_1 A1 A2 A3 A4 B1 VGND VNB VPB VPWR X
.ends

* Black-box entry subcircuit for sky130_fd_sc_hd__nor2b_1 abstract view
.subckt sky130_fd_sc_hd__nor2b_1 A B_N VGND VNB VPB VPWR Y
.ends

* Black-box entry subcircuit for sky130_fd_sc_hd__xor2_2 abstract view
.subckt sky130_fd_sc_hd__xor2_2 A B VGND VNB VPB VPWR X
.ends

* Black-box entry subcircuit for sky130_fd_sc_hd__o31a_1 abstract view
.subckt sky130_fd_sc_hd__o31a_1 A1 A2 A3 B1 VGND VNB VPB VPWR X
.ends

* Black-box entry subcircuit for sky130_fd_sc_hd__a21boi_2 abstract view
.subckt sky130_fd_sc_hd__a21boi_2 A1 A2 B1_N VGND VNB VPB VPWR Y
.ends

* Black-box entry subcircuit for sky130_fd_sc_hd__and2_0 abstract view
.subckt sky130_fd_sc_hd__and2_0 A B VGND VNB VPB VPWR X
.ends

* Black-box entry subcircuit for sky130_fd_sc_hd__xnor3_1 abstract view
.subckt sky130_fd_sc_hd__xnor3_1 A B C VGND VNB VPB VPWR X
.ends

* Black-box entry subcircuit for sky130_fd_sc_hd__o211ai_2 abstract view
.subckt sky130_fd_sc_hd__o211ai_2 A1 A2 B1 C1 VGND VNB VPB VPWR Y
.ends

* Black-box entry subcircuit for sky130_fd_sc_hd__o21ai_1 abstract view
.subckt sky130_fd_sc_hd__o21ai_1 A1 A2 B1 VGND VNB VPB VPWR Y
.ends

* Black-box entry subcircuit for sky130_fd_sc_hd__a311oi_2 abstract view
.subckt sky130_fd_sc_hd__a311oi_2 A1 A2 A3 B1 C1 VGND VNB VPB VPWR Y
.ends

* Black-box entry subcircuit for sky130_fd_sc_hd__or3b_1 abstract view
.subckt sky130_fd_sc_hd__or3b_1 A B C_N VGND VNB VPB VPWR X
.ends

* Black-box entry subcircuit for sky130_fd_sc_hd__o41ai_1 abstract view
.subckt sky130_fd_sc_hd__o41ai_1 A1 A2 A3 A4 B1 VGND VNB VPB VPWR Y
.ends

* Black-box entry subcircuit for sky130_fd_sc_hd__or4_4 abstract view
.subckt sky130_fd_sc_hd__or4_4 A B C D VGND VNB VPB VPWR X
.ends

* Black-box entry subcircuit for sky130_fd_sc_hd__o21bai_1 abstract view
.subckt sky130_fd_sc_hd__o21bai_1 A1 A2 B1_N VGND VNB VPB VPWR Y
.ends

* Black-box entry subcircuit for sky130_fd_sc_hd__a22oi_2 abstract view
.subckt sky130_fd_sc_hd__a22oi_2 A1 A2 B1 B2 VGND VNB VPB VPWR Y
.ends

* Black-box entry subcircuit for sky130_fd_sc_hd__a31oi_1 abstract view
.subckt sky130_fd_sc_hd__a31oi_1 A1 A2 A3 B1 VGND VNB VPB VPWR Y
.ends

* Black-box entry subcircuit for sky130_fd_sc_hd__nor2_4 abstract view
.subckt sky130_fd_sc_hd__nor2_4 A B VGND VNB VPB VPWR Y
.ends

* Black-box entry subcircuit for sky130_fd_sc_hd__nor3b_1 abstract view
.subckt sky130_fd_sc_hd__nor3b_1 A B C_N VGND VNB VPB VPWR Y
.ends

* Black-box entry subcircuit for sky130_fd_sc_hd__a211oi_1 abstract view
.subckt sky130_fd_sc_hd__a211oi_1 A1 A2 B1 C1 VGND VNB VPB VPWR Y
.ends

* Black-box entry subcircuit for sky130_fd_sc_hd__or3_1 abstract view
.subckt sky130_fd_sc_hd__or3_1 A B C VGND VNB VPB VPWR X
.ends

* Black-box entry subcircuit for sky130_fd_sc_hd__clkbuf_8 abstract view
.subckt sky130_fd_sc_hd__clkbuf_8 A VGND VNB VPB VPWR X
.ends

* Black-box entry subcircuit for sky130_fd_sc_hd__a32oi_1 abstract view
.subckt sky130_fd_sc_hd__a32oi_1 A1 A2 A3 B1 B2 VGND VNB VPB VPWR Y
.ends

* Black-box entry subcircuit for sky130_fd_sc_hd__a21oi_2 abstract view
.subckt sky130_fd_sc_hd__a21oi_2 A1 A2 B1 VGND VNB VPB VPWR Y
.ends

* Black-box entry subcircuit for sky130_fd_sc_hd__and4b_1 abstract view
.subckt sky130_fd_sc_hd__and4b_1 A_N B C D VGND VNB VPB VPWR X
.ends

* Black-box entry subcircuit for sky130_fd_sc_hd__inv_1 abstract view
.subckt sky130_fd_sc_hd__inv_1 A VGND VNB VPB VPWR Y
.ends

* Black-box entry subcircuit for sky130_fd_sc_hd__o2111ai_2 abstract view
.subckt sky130_fd_sc_hd__o2111ai_2 A1 A2 B1 C1 D1 VGND VNB VPB VPWR Y
.ends

* Black-box entry subcircuit for sky130_fd_sc_hd__o22a_1 abstract view
.subckt sky130_fd_sc_hd__o22a_1 A1 A2 B1 B2 VGND VNB VPB VPWR X
.ends

* Black-box entry subcircuit for sky130_fd_sc_hd__nand4b_4 abstract view
.subckt sky130_fd_sc_hd__nand4b_4 A_N B C D VGND VNB VPB VPWR Y
.ends

* Black-box entry subcircuit for sky130_fd_sc_hd__nor4_2 abstract view
.subckt sky130_fd_sc_hd__nor4_2 A B C D VGND VNB VPB VPWR Y
.ends

* Black-box entry subcircuit for sky130_fd_sc_hd__nor4bb_2 abstract view
.subckt sky130_fd_sc_hd__nor4bb_2 A B C_N D_N VGND VNB VPB VPWR Y
.ends

* Black-box entry subcircuit for sky130_fd_sc_hd__a211o_1 abstract view
.subckt sky130_fd_sc_hd__a211o_1 A1 A2 B1 C1 VGND VNB VPB VPWR X
.ends

* Black-box entry subcircuit for sky130_fd_sc_hd__a41oi_2 abstract view
.subckt sky130_fd_sc_hd__a41oi_2 A1 A2 A3 A4 B1 VGND VNB VPB VPWR Y
.ends

* Black-box entry subcircuit for sky130_fd_sc_hd__and3b_2 abstract view
.subckt sky130_fd_sc_hd__and3b_2 A_N B C VGND VNB VPB VPWR X
.ends

* Black-box entry subcircuit for sky130_fd_sc_hd__nand4_4 abstract view
.subckt sky130_fd_sc_hd__nand4_4 A B C D VGND VNB VPB VPWR Y
.ends

* Black-box entry subcircuit for sky130_fd_sc_hd__and2_2 abstract view
.subckt sky130_fd_sc_hd__and2_2 A B VGND VNB VPB VPWR X
.ends

* Black-box entry subcircuit for sky130_fd_sc_hd__a32o_1 abstract view
.subckt sky130_fd_sc_hd__a32o_1 A1 A2 A3 B1 B2 VGND VNB VPB VPWR X
.ends

* Black-box entry subcircuit for sky130_fd_sc_hd__and4_4 abstract view
.subckt sky130_fd_sc_hd__and4_4 A B C D VGND VNB VPB VPWR X
.ends

* Black-box entry subcircuit for sky130_fd_sc_hd__a41oi_1 abstract view
.subckt sky130_fd_sc_hd__a41oi_1 A1 A2 A3 A4 B1 VGND VNB VPB VPWR Y
.ends

* Black-box entry subcircuit for sky130_fd_sc_hd__a21boi_1 abstract view
.subckt sky130_fd_sc_hd__a21boi_1 A1 A2 B1_N VGND VNB VPB VPWR Y
.ends

* Black-box entry subcircuit for sky130_fd_sc_hd__nor3_4 abstract view
.subckt sky130_fd_sc_hd__nor3_4 A B C VGND VNB VPB VPWR Y
.ends

* Black-box entry subcircuit for sky130_fd_sc_hd__o2111ai_1 abstract view
.subckt sky130_fd_sc_hd__o2111ai_1 A1 A2 B1 C1 D1 VGND VNB VPB VPWR Y
.ends

* Black-box entry subcircuit for sky130_fd_sc_hd__o311ai_2 abstract view
.subckt sky130_fd_sc_hd__o311ai_2 A1 A2 A3 B1 C1 VGND VNB VPB VPWR Y
.ends

* Black-box entry subcircuit for sky130_fd_sc_hd__or3_4 abstract view
.subckt sky130_fd_sc_hd__or3_4 A B C VGND VNB VPB VPWR X
.ends

* Black-box entry subcircuit for sky130_fd_sc_hd__lpflow_inputiso1p_1 abstract view
.subckt sky130_fd_sc_hd__lpflow_inputiso1p_1 A SLEEP VGND VNB VPB VPWR X
.ends

* Black-box entry subcircuit for sky130_fd_sc_hd__a2111oi_1 abstract view
.subckt sky130_fd_sc_hd__a2111oi_1 A1 A2 B1 C1 D1 VGND VNB VPB VPWR Y
.ends

* Black-box entry subcircuit for sky130_fd_sc_hd__o211ai_1 abstract view
.subckt sky130_fd_sc_hd__o211ai_1 A1 A2 B1 C1 VGND VNB VPB VPWR Y
.ends

* Black-box entry subcircuit for sky130_fd_sc_hd__and3_2 abstract view
.subckt sky130_fd_sc_hd__and3_2 A B C VGND VNB VPB VPWR X
.ends

* Black-box entry subcircuit for sky130_fd_sc_hd__a31o_1 abstract view
.subckt sky130_fd_sc_hd__a31o_1 A1 A2 A3 B1 VGND VNB VPB VPWR X
.ends

* Black-box entry subcircuit for sky130_fd_sc_hd__nand2b_2 abstract view
.subckt sky130_fd_sc_hd__nand2b_2 A_N B VGND VNB VPB VPWR Y
.ends

* Black-box entry subcircuit for sky130_fd_sc_hd__nand4_2 abstract view
.subckt sky130_fd_sc_hd__nand4_2 A B C D VGND VNB VPB VPWR Y
.ends

* Black-box entry subcircuit for sky130_fd_sc_hd__a21oi_4 abstract view
.subckt sky130_fd_sc_hd__a21oi_4 A1 A2 B1 VGND VNB VPB VPWR Y
.ends

* Black-box entry subcircuit for sky130_fd_sc_hd__a311oi_1 abstract view
.subckt sky130_fd_sc_hd__a311oi_1 A1 A2 A3 B1 C1 VGND VNB VPB VPWR Y
.ends

* Black-box entry subcircuit for sky130_fd_sc_hd__dlymetal6s2s_1 abstract view
.subckt sky130_fd_sc_hd__dlymetal6s2s_1 A VGND VNB VPB VPWR X
.ends

* Black-box entry subcircuit for sky130_fd_sc_hd__inv_2 abstract view
.subckt sky130_fd_sc_hd__inv_2 A VGND VNB VPB VPWR Y
.ends

* Black-box entry subcircuit for sky130_fd_sc_hd__or3_2 abstract view
.subckt sky130_fd_sc_hd__or3_2 A B C VGND VNB VPB VPWR X
.ends

* Black-box entry subcircuit for sky130_fd_sc_hd__o31ai_2 abstract view
.subckt sky130_fd_sc_hd__o31ai_2 A1 A2 A3 B1 VGND VNB VPB VPWR Y
.ends

* Black-box entry subcircuit for sky130_fd_sc_hd__a221oi_4 abstract view
.subckt sky130_fd_sc_hd__a221oi_4 A1 A2 B1 B2 C1 VGND VNB VPB VPWR Y
.ends

.subckt uart_top VGND VPWR addr[0] addr[1] addr[2] break_int clk cts_in dcd_in dr
+ dsr_in dtr framing_err irq out1 out2 parity_err rd_en rdata[0] rdata[1] rdata[2]
+ rdata[3] rdata[4] rdata[5] rdata[6] rdata[7] ri_in rst_n rts rx_in temt thre tx_out
+ wdata[0] wdata[1] wdata[2] wdata[3] wdata[4] wdata[5] wdata[6] wdata[7] wr_en
XFILLER_0_27_71 VGND VGND VPWR VPWR sky130_fd_sc_hd__fill_2
XTAP_199 VGND VPWR sky130_fd_sc_hd__tapvpwrvgnd_1
XTAP_188 VGND VPWR sky130_fd_sc_hd__tapvpwrvgnd_1
XTAP_177 VGND VPWR sky130_fd_sc_hd__tapvpwrvgnd_1
X_2037_ _0951_ _0954_ VGND VGND VPWR VPWR _0955_ sky130_fd_sc_hd__nand2_1
X_2106_ net226 net224 net230 net228 VGND VGND VPWR VPWR _1005_ sky130_fd_sc_hd__and4b_4
XFILLER_0_76_177 VPWR VGND VPWR VGND sky130_ef_sc_hd__decap_12
XFILLER_0_64_306 VGND VGND VPWR VPWR sky130_fd_sc_hd__fill_2
XFILLER_0_57_391 VGND VGND VPWR VPWR sky130_fd_sc_hd__fill_1
X_2939_ clknet_leaf_34_clk net337 net256 VGND VGND VPWR VPWR rx.bit_cnt\[0\] sky130_fd_sc_hd__dfrtp_4
XFILLER_0_7_81 VGND VGND VPWR VPWR sky130_fd_sc_hd__decap_4
XFILLER_0_70_309 VPWR VGND VPWR VGND sky130_ef_sc_hd__decap_12
XFILLER_0_23_225 VGND VGND VPWR VPWR sky130_fd_sc_hd__decap_6
XFILLER_0_48_26 VGND VGND VPWR VPWR sky130_fd_sc_hd__fill_2
X_1270_ tx_fifo.count\[4\] tx.tx_busy _0513_ VGND VGND VPWR VPWR net33 sky130_fd_sc_hd__nor3_1
XFILLER_0_73_169 VGND VGND VPWR VPWR sky130_fd_sc_hd__decap_8
X_2655_ clknet_leaf_20_clk _0211_ net97 VGND VGND VPWR VPWR rx_fifo.fifo\[13\]\[7\]
+ sky130_fd_sc_hd__edfxtp_1
X_1606_ rx_fifo.fifo\[4\]\[1\] net173 net172 rx_fifo.fifo\[7\]\[1\] _0809_ VGND VGND
+ VPWR VPWR _0810_ sky130_fd_sc_hd__a221o_1
X_2724_ clknet_leaf_5_clk _0494_ net49 VGND VGND VPWR VPWR tx_fifo.fifo\[0\]\[1\]
+ sky130_fd_sc_hd__edfxtp_1
X_1537_ _0739_ _0740_ _0743_ _0744_ VGND VGND VPWR VPWR _0745_ sky130_fd_sc_hd__nand4_1
X_1399_ tx.baud_cnt\[14\] _0637_ VGND VGND VPWR VPWR _0638_ sky130_fd_sc_hd__xnor2_1
X_2586_ clknet_leaf_14_clk _0219_ net82 VGND VGND VPWR VPWR rx_fifo.fifo\[12\]\[4\]
+ sky130_fd_sc_hd__edfxtp_1
Xfanout116 _0845_ VGND VGND VPWR VPWR net116 sky130_fd_sc_hd__clkbuf_2
X_1468_ _0683_ _0684_ _0687_ _0688_ _0681_ VGND VGND VPWR VPWR _0689_ sky130_fd_sc_hd__o2111a_1
Xfanout105 net106 VGND VGND VPWR VPWR net105 sky130_fd_sc_hd__clkbuf_4
Xfanout149 _0868_ VGND VGND VPWR VPWR net149 sky130_fd_sc_hd__buf_4
XFILLER_0_1_163 VGND VGND VPWR VPWR sky130_fd_sc_hd__decap_4
XFILLER_0_37_306 VGND VGND VPWR VPWR sky130_fd_sc_hd__fill_2
XFILLER_0_64_103 VPWR VGND VPWR VGND sky130_ef_sc_hd__decap_12
XFILLER_0_52_309 VGND VGND VPWR VPWR sky130_fd_sc_hd__fill_1
XFILLER_0_37_317 VGND VGND VPWR VPWR sky130_fd_sc_hd__decap_3
XFILLER_0_18_29 VGND VGND VPWR VPWR sky130_fd_sc_hd__decap_8
XFILLER_0_3_417 VPWR VGND VPWR VGND sky130_ef_sc_hd__decap_12
X_2440_ _1112_ _1203_ VGND VGND VPWR VPWR _1204_ sky130_fd_sc_hd__nand2_1
XFILLER_0_75_79 VGND VGND VPWR VPWR sky130_fd_sc_hd__decap_8
XFILLER_0_75_57 VPWR VGND VPWR VGND sky130_ef_sc_hd__decap_12
X_1322_ rx_fifo.fifo\[3\]\[8\] net176 net170 rx_fifo.fifo\[14\]\[8\] net163 rx_fifo.fifo\[5\]\[8\]
+ VGND VGND VPWR VPWR _0562_ sky130_fd_sc_hd__a222oi_1
X_2371_ tx_fifo.count\[4\] _0513_ _1027_ _1038_ VGND VGND VPWR VPWR _1169_ sky130_fd_sc_hd__o22ai_1
XFILLER_0_74_445 VPWR VGND VPWR VGND sky130_ef_sc_hd__decap_12
XFILLER_0_34_309 VPWR VGND VPWR VGND sky130_ef_sc_hd__decap_12
XFILLER_0_27_361 VGND VGND VPWR VPWR sky130_fd_sc_hd__fill_2
XFILLER_0_24_61 VGND VGND VPWR VPWR sky130_fd_sc_hd__fill_1
XFILLER_0_6_244 VGND VGND VPWR VPWR sky130_fd_sc_hd__decap_8
X_2638_ clknet_leaf_21_clk _0282_ net98 VGND VGND VPWR VPWR rx_fifo.fifo\[6\]\[1\]
+ sky130_fd_sc_hd__edfxtp_1
XFILLER_0_71_3 VPWR VGND VPWR VGND sky130_ef_sc_hd__decap_12
X_2569_ clknet_leaf_17_clk _0345_ net85 VGND VGND VPWR VPWR rx_fifo.fifo\[1\]\[9\]
+ sky130_fd_sc_hd__edfxtp_1
X_2707_ clknet_leaf_3_clk _0381_ _0015_ VGND VGND VPWR VPWR tx_fifo.fifo\[14\]\[0\]
+ sky130_fd_sc_hd__edfxtp_1
XFILLER_0_65_90 VGND VGND VPWR VPWR sky130_fd_sc_hd__fill_1
XFILLER_0_37_169 VGND VGND VPWR VPWR sky130_fd_sc_hd__fill_1
XFILLER_0_20_19 VGND VGND VPWR VPWR sky130_fd_sc_hd__decap_8
XFILLER_0_45_27 VPWR VGND VPWR VGND sky130_ef_sc_hd__decap_12
XFILLER_0_0_29 VGND VGND VPWR VPWR sky130_fd_sc_hd__decap_8
Xmax_cap5 _1000_ VGND VGND VPWR VPWR net384 sky130_fd_sc_hd__clkbuf_1
XFILLER_0_71_415 VGND VGND VPWR VPWR sky130_fd_sc_hd__decap_4
XFILLER_0_68_294 VPWR VGND VPWR VGND sky130_ef_sc_hd__decap_12
X_1871_ net62 _0891_ VGND VGND VPWR VPWR _0390_ sky130_fd_sc_hd__nor2_1
X_1940_ _0892_ net202 VGND VGND VPWR VPWR _0903_ sky130_fd_sc_hd__nand2_4
XFILLER_0_51_150 VGND VGND VPWR VPWR sky130_fd_sc_hd__fill_1
X_2423_ regs.rx_fifo_pop net124 _1097_ rx_fifo.count\[3\] VGND VGND VPWR VPWR _1197_
+ sky130_fd_sc_hd__nor4b_1
XFILLER_0_10_41 VPWR VGND VPWR VGND sky130_ef_sc_hd__decap_12
XFILLER_0_10_85 VGND VGND VPWR VPWR sky130_fd_sc_hd__decap_8
X_1305_ _0543_ _0546_ VGND VGND VPWR VPWR _0547_ sky130_fd_sc_hd__nor2_1
X_2285_ net266 net12 _0160_ VGND VGND VPWR VPWR _0109_ sky130_fd_sc_hd__mux2_1
X_2354_ net218 _0908_ net58 VGND VGND VPWR VPWR _0013_ sky130_fd_sc_hd__nor3_2
XFILLER_0_74_264 VGND VGND VPWR VPWR sky130_fd_sc_hd__fill_2
XFILLER_0_42_161 VPWR VGND VPWR VGND sky130_ef_sc_hd__decap_12
XFILLER_0_27_180 VGND VGND VPWR VPWR sky130_fd_sc_hd__decap_6
XFILLER_0_19_169 VGND VGND VPWR VPWR sky130_fd_sc_hd__decap_3
XFILLER_0_30_356 VGND VGND VPWR VPWR sky130_fd_sc_hd__decap_3
XFILLER_0_65_275 VGND VGND VPWR VPWR sky130_fd_sc_hd__decap_4
Xwire133 _0723_ VGND VGND VPWR VPWR net133 sky130_fd_sc_hd__clkbuf_1
XTAP_507 VGND VPWR sky130_fd_sc_hd__tapvpwrvgnd_1
Xwire144 _1025_ VGND VGND VPWR VPWR net144 sky130_fd_sc_hd__clkbuf_1
XTAP_529 VGND VPWR sky130_fd_sc_hd__tapvpwrvgnd_1
XTAP_518 VGND VPWR sky130_fd_sc_hd__tapvpwrvgnd_1
X_2070_ _0968_ _0969_ VGND VGND VPWR VPWR _0979_ sky130_fd_sc_hd__nand2_1
X_2972_ clknet_leaf_8_clk _0174_ net244 VGND VGND VPWR VPWR rx.baud_cnt\[7\] sky130_fd_sc_hd__dfrtp_1
XFILLER_0_8_317 VGND VGND VPWR VPWR sky130_fd_sc_hd__fill_1
X_1785_ net107 net149 VGND VGND VPWR VPWR _0306_ sky130_fd_sc_hd__nor2_1
XFILLER_0_71_223 VGND VGND VPWR VPWR sky130_fd_sc_hd__fill_1
XFILLER_0_71_212 VGND VGND VPWR VPWR sky130_fd_sc_hd__decap_4
XFILLER_0_56_253 VPWR VGND VPWR VGND sky130_ef_sc_hd__decap_12
X_1923_ net61 _0900_ VGND VGND VPWR VPWR _0437_ sky130_fd_sc_hd__nor2_1
X_1854_ _0879_ net60 VGND VGND VPWR VPWR _0373_ sky130_fd_sc_hd__nor2_1
X_2406_ net156 net90 VGND VGND VPWR VPWR _0226_ sky130_fd_sc_hd__nor2_1
X_2268_ net13 net330 _1132_ VGND VGND VPWR VPWR _0094_ sky130_fd_sc_hd__mux2_1
X_2337_ net221 net146 _1164_ VGND VGND VPWR VPWR _0028_ sky130_fd_sc_hd__nor3_2
X_2199_ net234 _1086_ _1087_ VGND VGND VPWR VPWR _0070_ sky130_fd_sc_hd__o21a_1
XFILLER_0_34_3 VPWR VGND VPWR VGND sky130_ef_sc_hd__decap_12
XFILLER_0_35_426 VPWR VGND VPWR VGND sky130_ef_sc_hd__decap_12
XFILLER_0_30_153 VGND VGND VPWR VPWR sky130_fd_sc_hd__decap_3
XFILLER_0_15_150 VPWR VGND VPWR VGND sky130_ef_sc_hd__decap_12
Xhold74 regs.ier\[2\] VGND VGND VPWR VPWR net335 sky130_fd_sc_hd__dlygate4sd3_1
XFILLER_0_30_197 VPWR VGND VPWR VGND sky130_ef_sc_hd__decap_12
XFILLER_0_26_29 VGND VGND VPWR VPWR sky130_fd_sc_hd__decap_4
Xhold30 _0055_ VGND VGND VPWR VPWR net291 sky130_fd_sc_hd__dlygate4sd3_1
Xhold52 tx_fifo.fifo\[3\]\[3\] VGND VGND VPWR VPWR net313 sky130_fd_sc_hd__dlygate4sd3_1
Xhold63 rx.break_int_lat VGND VGND VPWR VPWR net324 sky130_fd_sc_hd__buf_1
Xhold41 _0065_ VGND VGND VPWR VPWR net302 sky130_fd_sc_hd__dlygate4sd3_1
Xhold85 divisor\[2\] VGND VGND VPWR VPWR net346 sky130_fd_sc_hd__dlygate4sd3_1
Xhold96 divisor\[0\] VGND VGND VPWR VPWR net357 sky130_fd_sc_hd__dlygate4sd3_1
XFILLER_0_38_253 VPWR VGND VPWR VGND sky130_ef_sc_hd__decap_12
XFILLER_0_26_404 VPWR VGND VPWR VGND sky130_ef_sc_hd__decap_12
XFILLER_0_67_69 VPWR VGND VPWR VGND sky130_ef_sc_hd__decap_12
XFILLER_0_67_25 VGND VGND VPWR VPWR sky130_fd_sc_hd__fill_1
X_1570_ rx_fifo.fifo\[0\]\[3\] net215 net172 rx_fifo.fifo\[7\]\[3\] _0775_ VGND VGND
+ VPWR VPWR _0776_ sky130_fd_sc_hd__a221o_1
XTAP_348 VGND VPWR sky130_fd_sc_hd__tapvpwrvgnd_1
XTAP_337 VGND VPWR sky130_fd_sc_hd__tapvpwrvgnd_1
XFILLER_0_21_186 VGND VGND VPWR VPWR sky130_fd_sc_hd__decap_3
XANTENNA_5 net27 VGND VGND VPWR VPWR sky130_fd_sc_hd__diode_2
XTAP_304 VGND VPWR sky130_fd_sc_hd__tapvpwrvgnd_1
XTAP_315 VGND VPWR sky130_fd_sc_hd__tapvpwrvgnd_1
XTAP_326 VGND VPWR sky130_fd_sc_hd__tapvpwrvgnd_1
XTAP_359 VGND VPWR sky130_fd_sc_hd__tapvpwrvgnd_1
X_2122_ tx_fifo.fifo\[10\]\[5\] net195 _1001_ tx_fifo.fifo\[9\]\[5\] VGND VGND VPWR
+ VPWR _1020_ sky130_fd_sc_hd__a22o_1
X_2053_ net345 net351 _0967_ VGND VGND VPWR VPWR _0045_ sky130_fd_sc_hd__mux2_1
XFILLER_0_76_348 VPWR VGND VPWR VGND sky130_ef_sc_hd__decap_12
X_2955_ clknet_leaf_37_clk net322 net256 VGND VGND VPWR VPWR net35 sky130_fd_sc_hd__dfstp_2
XFILLER_0_8_147 VGND VGND VPWR VPWR sky130_fd_sc_hd__fill_1
X_1768_ net119 _0867_ VGND VGND VPWR VPWR _0301_ sky130_fd_sc_hd__nor2_1
X_2886_ clknet_leaf_12_clk net326 net245 VGND VGND VPWR VPWR divisor\[10\] sky130_fd_sc_hd__dfrtp_1
X_1906_ net60 _0897_ VGND VGND VPWR VPWR _0421_ sky130_fd_sc_hd__nor2_1
X_1837_ _0874_ _0875_ regs.tx_start VGND VGND VPWR VPWR _0877_ sky130_fd_sc_hd__o21ai_2
X_1699_ rx_fifo.tail\[3\] rx_fifo.tail\[2\] VGND VGND VPWR VPWR _0859_ sky130_fd_sc_hd__lpflow_isobufsrc_1
XFILLER_0_12_197 VGND VGND VPWR VPWR sky130_fd_sc_hd__fill_1
XFILLER_0_67_337 VGND VGND VPWR VPWR sky130_fd_sc_hd__fill_1
XFILLER_0_35_245 VGND VGND VPWR VPWR sky130_fd_sc_hd__decap_8
Xoutput20 net20 VGND VGND VPWR VPWR irq sky130_fd_sc_hd__clkbuf_4
XFILLER_0_31_440 VGND VGND VPWR VPWR sky130_fd_sc_hd__fill_2
Xoutput31 net31 VGND VGND VPWR VPWR rdata[7] sky130_fd_sc_hd__clkbuf_4
XFILLER_0_58_315 VPWR VGND VPWR VGND sky130_ef_sc_hd__decap_12
XFILLER_0_26_201 VGND VGND VPWR VPWR sky130_fd_sc_hd__fill_1
X_1622_ net236 _0509_ _0823_ VGND VGND VPWR VPWR _0824_ sky130_fd_sc_hd__o21ai_0
X_2671_ clknet_leaf_29_clk _0260_ net95 VGND VGND VPWR VPWR rx_fifo.fifo\[8\]\[1\]
+ sky130_fd_sc_hd__edfxtp_1
X_2740_ clknet_leaf_43_clk _0478_ net47 VGND VGND VPWR VPWR tx_fifo.fifo\[2\]\[1\]
+ sky130_fd_sc_hd__edfxtp_1
XFILLER_0_14_429 VGND VGND VPWR VPWR sky130_fd_sc_hd__decap_8
X_1553_ rx_fifo.fifo\[12\]\[4\] net165 _0535_ rx_fifo.fifo\[15\]\[4\] VGND VGND VPWR
+ VPWR _0760_ sky130_fd_sc_hd__a22oi_1
X_1484_ _0657_ net74 _0703_ VGND VGND VPWR VPWR _0162_ sky130_fd_sc_hd__nor3_1
XTAP_189 VGND VPWR sky130_fd_sc_hd__tapvpwrvgnd_1
XTAP_178 VGND VPWR sky130_fd_sc_hd__tapvpwrvgnd_1
XTAP_167 VGND VPWR sky130_fd_sc_hd__tapvpwrvgnd_1
XTAP_156 VGND VPWR sky130_fd_sc_hd__tapvpwrvgnd_1
X_2105_ net230 net224 net226 net228 VGND VGND VPWR VPWR _1004_ sky130_fd_sc_hd__and4b_4
XFILLER_0_9_401 VGND VGND VPWR VPWR sky130_fd_sc_hd__decap_8
X_2036_ _0937_ _0948_ _0953_ VGND VGND VPWR VPWR _0954_ sky130_fd_sc_hd__a21oi_1
XFILLER_0_76_189 VGND VGND VPWR VPWR sky130_fd_sc_hd__decap_6
XFILLER_0_72_362 VGND VGND VPWR VPWR sky130_fd_sc_hd__fill_2
XFILLER_0_64_318 VGND VGND VPWR VPWR sky130_fd_sc_hd__decap_8
X_2938_ clknet_leaf_33_clk _0148_ net257 VGND VGND VPWR VPWR rx.shift_reg\[7\] sky130_fd_sc_hd__dfrtp_1
XFILLER_0_17_223 VGND VGND VPWR VPWR sky130_fd_sc_hd__fill_1
XFILLER_0_17_278 VGND VGND VPWR VPWR sky130_fd_sc_hd__fill_2
X_2869_ clknet_leaf_15_clk _0099_ net250 VGND VGND VPWR VPWR regs.dlh\[1\] sky130_fd_sc_hd__dfrtp_1
XFILLER_0_4_150 VGND VGND VPWR VPWR sky130_fd_sc_hd__fill_1
XTAP_690 VGND VPWR sky130_fd_sc_hd__tapvpwrvgnd_1
XFILLER_0_67_167 VGND VGND VPWR VPWR sky130_fd_sc_hd__fill_1
XFILLER_0_67_134 VGND VGND VPWR VPWR sky130_fd_sc_hd__fill_1
XFILLER_0_67_101 VGND VGND VPWR VPWR sky130_fd_sc_hd__decap_4
XFILLER_0_63_340 VGND VGND VPWR VPWR sky130_fd_sc_hd__fill_2
XFILLER_0_23_215 VGND VGND VPWR VPWR sky130_fd_sc_hd__decap_8
XFILLER_0_73_104 VGND VGND VPWR VPWR sky130_fd_sc_hd__decap_8
X_2723_ clknet_leaf_3_clk _0493_ net49 VGND VGND VPWR VPWR tx_fifo.fifo\[0\]\[0\]
+ sky130_fd_sc_hd__edfxtp_1
XFILLER_0_13_96 VGND VGND VPWR VPWR sky130_fd_sc_hd__fill_1
X_2654_ clknet_leaf_19_clk _0210_ net97 VGND VGND VPWR VPWR rx_fifo.fifo\[13\]\[6\]
+ sky130_fd_sc_hd__edfxtp_1
X_1536_ rx_fifo.fifo\[13\]\[5\] net175 net168 rx_fifo.fifo\[1\]\[5\] net164 rx_fifo.fifo\[15\]\[5\]
+ VGND VGND VPWR VPWR _0744_ sky130_fd_sc_hd__a222oi_1
X_1605_ _0806_ _0807_ _0808_ VGND VGND VPWR VPWR _0809_ sky130_fd_sc_hd__nand3_1
X_2585_ clknet_leaf_27_clk _0218_ net82 VGND VGND VPWR VPWR rx_fifo.fifo\[12\]\[3\]
+ sky130_fd_sc_hd__edfxtp_1
XFILLER_0_1_175 VGND VGND VPWR VPWR sky130_fd_sc_hd__fill_1
XFILLER_0_10_421 VGND VGND VPWR VPWR sky130_fd_sc_hd__fill_1
XFILLER_0_14_248 VGND VGND VPWR VPWR sky130_fd_sc_hd__decap_4
X_1398_ tx.baud_cnt\[13\] _0636_ VGND VGND VPWR VPWR _0637_ sky130_fd_sc_hd__and2_1
X_1467_ divisor\[4\] rx.baud_cnt\[0\] _0685_ VGND VGND VPWR VPWR _0688_ sky130_fd_sc_hd__mux2_1
Xfanout117 net118 VGND VGND VPWR VPWR net117 sky130_fd_sc_hd__clkbuf_4
Xfanout106 _0850_ VGND VGND VPWR VPWR net106 sky130_fd_sc_hd__clkbuf_4
XFILLER_0_77_421 VGND VGND VPWR VPWR sky130_fd_sc_hd__fill_2
XFILLER_0_64_115 VGND VGND VPWR VPWR sky130_fd_sc_hd__decap_4
XFILLER_0_49_167 VGND VGND VPWR VPWR sky130_fd_sc_hd__fill_1
XFILLER_0_37_329 VGND VGND VPWR VPWR sky130_fd_sc_hd__decap_4
X_2019_ net232 rx.state\[1\] VGND VGND VPWR VPWR _0937_ sky130_fd_sc_hd__nand2b_1
XFILLER_0_60_365 VPWR VGND VPWR VGND sky130_ef_sc_hd__decap_12
XFILLER_0_68_421 VGND VGND VPWR VPWR sky130_fd_sc_hd__decap_8
XFILLER_0_34_29 VPWR VGND VPWR VGND sky130_ef_sc_hd__decap_12
XFILLER_0_59_37 VPWR VGND VPWR VGND sky130_ef_sc_hd__decap_12
XFILLER_0_59_15 VPWR VGND VPWR VGND sky130_ef_sc_hd__decap_12
XFILLER_0_3_429 VPWR VGND VPWR VGND sky130_ef_sc_hd__decap_12
XFILLER_0_75_69 VGND VGND VPWR VPWR sky130_fd_sc_hd__decap_6
X_1321_ rx_fifo.fifo\[13\]\[8\] net175 net173 rx_fifo.fifo\[4\]\[8\] _0560_ VGND VGND
+ VPWR VPWR _0561_ sky130_fd_sc_hd__a221oi_2
X_2370_ _0628_ _1168_ _1112_ VGND VGND VPWR VPWR _0130_ sky130_fd_sc_hd__o21ai_0
XFILLER_0_74_457 VGND VGND VPWR VPWR sky130_fd_sc_hd__decap_6
XFILLER_0_46_137 VGND VGND VPWR VPWR sky130_fd_sc_hd__decap_3
XFILLER_0_42_321 VGND VGND VPWR VPWR sky130_fd_sc_hd__fill_1
X_2706_ clknet_leaf_34_clk _0141_ net253 VGND VGND VPWR VPWR rx.sample_cnt\[3\] sky130_fd_sc_hd__dfrtp_1
X_2637_ clknet_leaf_19_clk _0280_ net98 VGND VGND VPWR VPWR rx_fifo.fifo\[6\]\[0\]
+ sky130_fd_sc_hd__edfxtp_1
X_2568_ clknet_leaf_23_clk _0344_ net85 VGND VGND VPWR VPWR rx_fifo.fifo\[1\]\[8\]
+ sky130_fd_sc_hd__edfxtp_1
X_1519_ net2 net3 net1 VGND VGND VPWR VPWR _0728_ sky130_fd_sc_hd__nor3b_2
XFILLER_0_42_398 VGND VGND VPWR VPWR sky130_fd_sc_hd__decap_4
X_2499_ _0908_ net54 VGND VGND VPWR VPWR _0500_ sky130_fd_sc_hd__nor2_1
XFILLER_0_77_273 VGND VGND VPWR VPWR sky130_fd_sc_hd__decap_3
XFILLER_0_65_457 VGND VGND VPWR VPWR sky130_fd_sc_hd__fill_2
XFILLER_0_52_107 VGND VGND VPWR VPWR sky130_fd_sc_hd__decap_8
XFILLER_0_18_362 VGND VGND VPWR VPWR sky130_fd_sc_hd__fill_2
XFILLER_0_60_173 VGND VGND VPWR VPWR sky130_fd_sc_hd__fill_1
XFILLER_0_33_354 VGND VGND VPWR VPWR sky130_fd_sc_hd__fill_1
XFILLER_0_45_39 VPWR VGND VPWR VGND sky130_ef_sc_hd__decap_12
Xmax_cap6 _0998_ VGND VGND VPWR VPWR net385 sky130_fd_sc_hd__buf_1
XFILLER_0_71_449 VPWR VGND VPWR VGND sky130_ef_sc_hd__decap_12
XFILLER_0_43_107 VGND VGND VPWR VPWR sky130_fd_sc_hd__decap_4
XFILLER_0_36_192 VGND VGND VPWR VPWR sky130_fd_sc_hd__decap_4
X_1870_ net64 _0891_ VGND VGND VPWR VPWR _0391_ sky130_fd_sc_hd__nor2_1
XFILLER_0_51_173 VGND VGND VPWR VPWR sky130_fd_sc_hd__fill_1
X_2422_ net145 net90 VGND VGND VPWR VPWR _0347_ sky130_fd_sc_hd__nor2_1
XFILLER_0_10_53 VPWR VGND VPWR VGND sky130_ef_sc_hd__decap_12
X_2353_ net219 _0895_ net58 VGND VGND VPWR VPWR _0014_ sky130_fd_sc_hd__nor3_1
X_1304_ _0544_ _0545_ VGND VGND VPWR VPWR _0546_ sky130_fd_sc_hd__nand2_1
X_2284_ net279 net13 net123 VGND VGND VPWR VPWR _0108_ sky130_fd_sc_hd__mux2_1
XFILLER_0_51_82 VPWR VGND VPWR VGND sky130_ef_sc_hd__decap_12
XFILLER_0_42_195 VGND VGND VPWR VPWR sky130_fd_sc_hd__fill_1
XFILLER_0_42_173 VPWR VGND VPWR VGND sky130_ef_sc_hd__decap_12
X_1999_ tx_fifo.count\[3\] _0920_ VGND VGND VPWR VPWR _0921_ sky130_fd_sc_hd__nand2_1
XFILLER_0_15_365 VGND VGND VPWR VPWR sky130_fd_sc_hd__decap_6
XFILLER_0_53_449 VPWR VGND VPWR VGND sky130_ef_sc_hd__decap_12
XFILLER_0_31_19 VGND VGND VPWR VPWR sky130_fd_sc_hd__decap_3
XFILLER_0_25_118 VGND VGND VPWR VPWR sky130_fd_sc_hd__fill_2
XTAP_519 VGND VPWR sky130_fd_sc_hd__tapvpwrvgnd_1
XTAP_508 VGND VPWR sky130_fd_sc_hd__tapvpwrvgnd_1
Xwire189 net190 VGND VGND VPWR VPWR net189 sky130_fd_sc_hd__clkbuf_2
XFILLER_0_72_15 VPWR VGND VPWR VGND sky130_ef_sc_hd__decap_12
X_2971_ clknet_leaf_9_clk _0173_ net244 VGND VGND VPWR VPWR rx.baud_cnt\[6\] sky130_fd_sc_hd__dfrtp_1
XFILLER_0_56_265 VPWR VGND VPWR VGND sky130_ef_sc_hd__decap_12
X_1922_ net63 _0900_ VGND VGND VPWR VPWR _0438_ sky130_fd_sc_hd__nor2_1
XFILLER_0_8_307 VGND VGND VPWR VPWR sky130_fd_sc_hd__fill_1
XFILLER_0_71_268 VPWR VGND VPWR VGND sky130_ef_sc_hd__decap_12
X_1784_ net109 net149 VGND VGND VPWR VPWR _0307_ sky130_fd_sc_hd__nor2_1
X_1853_ regs.tx_data\[0\] net76 VGND VGND VPWR VPWR _0887_ sky130_fd_sc_hd__nand2_1
X_2336_ net260 net126 VGND VGND VPWR VPWR _1164_ sky130_fd_sc_hd__nand2_2
XFILLER_0_12_368 VGND VGND VPWR VPWR sky130_fd_sc_hd__decap_4
X_2405_ net262 _0943_ _0947_ VGND VGND VPWR VPWR _0180_ sky130_fd_sc_hd__and3_1
X_2267_ net235 net15 net239 VGND VGND VPWR VPWR _1132_ sky130_fd_sc_hd__nand3_4
X_2198_ net234 _1086_ net222 VGND VGND VPWR VPWR _1087_ sky130_fd_sc_hd__a21oi_1
XFILLER_0_27_3 VGND VGND VPWR VPWR sky130_fd_sc_hd__decap_6
XFILLER_0_47_210 VGND VGND VPWR VPWR sky130_fd_sc_hd__decap_6
XFILLER_0_35_449 VPWR VGND VPWR VGND sky130_ef_sc_hd__decap_12
XFILLER_0_35_438 VGND VGND VPWR VPWR sky130_fd_sc_hd__decap_3
XFILLER_0_35_405 VGND VGND VPWR VPWR sky130_fd_sc_hd__fill_1
XFILLER_0_7_373 VPWR VGND VPWR VGND sky130_ef_sc_hd__decap_12
XFILLER_0_15_162 VGND VGND VPWR VPWR sky130_fd_sc_hd__decap_6
Xhold97 rx.baud_cnt\[6\] VGND VGND VPWR VPWR net358 sky130_fd_sc_hd__dlygate4sd3_1
Xhold64 divisor\[10\] VGND VGND VPWR VPWR net325 sky130_fd_sc_hd__dlygate4sd3_1
Xhold31 rx.baud_cnt\[14\] VGND VGND VPWR VPWR net292 sky130_fd_sc_hd__dlygate4sd3_1
Xhold42 regs.lcr\[6\] VGND VGND VPWR VPWR net303 sky130_fd_sc_hd__dlygate4sd3_1
XFILLER_0_26_19 VGND VGND VPWR VPWR sky130_fd_sc_hd__fill_1
Xhold20 regs.rx_data\[6\] VGND VGND VPWR VPWR net281 sky130_fd_sc_hd__dlygate4sd3_1
XFILLER_0_11_390 VGND VGND VPWR VPWR sky130_fd_sc_hd__fill_2
Xhold86 rx.shift_reg\[4\] VGND VGND VPWR VPWR net347 sky130_fd_sc_hd__dlygate4sd3_1
Xhold75 rx.bit_cnt\[0\] VGND VGND VPWR VPWR net336 sky130_fd_sc_hd__dlygate4sd3_1
Xhold53 regs.rx_data\[5\] VGND VGND VPWR VPWR net314 sky130_fd_sc_hd__dlygate4sd3_1
XFILLER_0_42_29 VPWR VGND VPWR VGND sky130_ef_sc_hd__decap_12
XFILLER_0_38_265 VPWR VGND VPWR VGND sky130_ef_sc_hd__decap_12
XANTENNA_6 _0026_ VGND VGND VPWR VPWR sky130_fd_sc_hd__diode_2
XFILLER_0_53_279 VGND VGND VPWR VPWR sky130_fd_sc_hd__fill_1
XFILLER_0_26_416 VGND VGND VPWR VPWR sky130_fd_sc_hd__decap_4
XTAP_349 VGND VPWR sky130_fd_sc_hd__tapvpwrvgnd_1
XTAP_338 VGND VPWR sky130_fd_sc_hd__tapvpwrvgnd_1
XFILLER_0_6_29 VPWR VGND VPWR VGND sky130_ef_sc_hd__decap_12
XTAP_305 VGND VPWR sky130_fd_sc_hd__tapvpwrvgnd_1
XTAP_316 VGND VPWR sky130_fd_sc_hd__tapvpwrvgnd_1
XTAP_327 VGND VPWR sky130_fd_sc_hd__tapvpwrvgnd_1
X_2121_ net263 _0991_ _0992_ tx.shift_reg\[6\] _1019_ VGND VGND VPWR VPWR _0060_ sky130_fd_sc_hd__a221o_1
X_2052_ net344 rx.shift_reg\[6\] _0967_ VGND VGND VPWR VPWR _0044_ sky130_fd_sc_hd__mux2_1
XFILLER_0_16_85 VGND VGND VPWR VPWR sky130_fd_sc_hd__decap_3
X_2885_ clknet_leaf_15_clk _0084_ net249 VGND VGND VPWR VPWR divisor\[9\] sky130_fd_sc_hd__dfrtp_4
XFILLER_0_44_213 VPWR VGND VPWR VGND sky130_ef_sc_hd__decap_12
XFILLER_0_44_202 VGND VGND VPWR VPWR sky130_fd_sc_hd__fill_2
XFILLER_0_32_95 VGND VGND VPWR VPWR sky130_fd_sc_hd__decap_8
X_2954_ clknet_leaf_1_clk _0152_ net240 VGND VGND VPWR VPWR tx_fifo.tail\[3\] sky130_fd_sc_hd__dfrtp_4
X_1905_ net62 _0897_ VGND VGND VPWR VPWR _0422_ sky130_fd_sc_hd__nor2_1
X_1698_ net101 _0858_ VGND VGND VPWR VPWR _0214_ sky130_fd_sc_hd__nor2_1
X_1767_ _0855_ net389 VGND VGND VPWR VPWR _0867_ sky130_fd_sc_hd__nand2_2
X_1836_ _0874_ _0875_ regs.tx_start VGND VGND VPWR VPWR _0876_ sky130_fd_sc_hd__o21a_2
X_2319_ _0973_ _1148_ _1149_ VGND VGND VPWR VPWR _1150_ sky130_fd_sc_hd__nand3_2
XFILLER_0_35_235 VGND VGND VPWR VPWR sky130_fd_sc_hd__decap_4
Xoutput21 net21 VGND VGND VPWR VPWR out1 sky130_fd_sc_hd__clkbuf_4
Xoutput32 net32 VGND VGND VPWR VPWR rts sky130_fd_sc_hd__buf_2
XFILLER_0_58_327 VGND VGND VPWR VPWR sky130_fd_sc_hd__decap_6
X_1552_ _0756_ net132 _0758_ VGND VGND VPWR VPWR _0759_ sky130_fd_sc_hd__and3_1
X_1621_ net236 regs.dlh\[0\] VGND VGND VPWR VPWR _0823_ sky130_fd_sc_hd__nand2_1
X_2670_ clknet_leaf_29_clk _0258_ net95 VGND VGND VPWR VPWR rx_fifo.fifo\[8\]\[0\]
+ sky130_fd_sc_hd__edfxtp_1
XFILLER_0_1_335 VGND VGND VPWR VPWR sky130_fd_sc_hd__fill_1
X_1483_ rx.baud_cnt\[10\] _0656_ VGND VGND VPWR VPWR _0703_ sky130_fd_sc_hd__nor2_1
XFILLER_0_27_40 VPWR VGND VPWR VGND sky130_ef_sc_hd__decap_12
X_2104_ net228 net224 net226 net230 VGND VGND VPWR VPWR _1003_ sky130_fd_sc_hd__nor4b_2
XTAP_179 VGND VPWR sky130_fd_sc_hd__tapvpwrvgnd_1
XTAP_168 VGND VPWR sky130_fd_sc_hd__tapvpwrvgnd_1
XTAP_157 VGND VPWR sky130_fd_sc_hd__tapvpwrvgnd_1
X_2035_ _0946_ _0952_ VGND VGND VPWR VPWR _0953_ sky130_fd_sc_hd__lpflow_isobufsrc_1
XFILLER_0_57_393 VGND VGND VPWR VPWR sky130_fd_sc_hd__fill_2
X_2868_ clknet_leaf_15_clk _0100_ net249 VGND VGND VPWR VPWR regs.dlh\[0\] sky130_fd_sc_hd__dfrtp_1
X_2937_ clknet_leaf_31_clk _0044_ net258 VGND VGND VPWR VPWR rx.shift_reg\[6\] sky130_fd_sc_hd__dfrtp_2
XFILLER_0_17_257 VGND VGND VPWR VPWR sky130_fd_sc_hd__fill_1
X_1819_ net108 net146 VGND VGND VPWR VPWR _0339_ sky130_fd_sc_hd__nor2_1
X_2799_ clknet_leaf_2_clk _0393_ net40 VGND VGND VPWR VPWR tx_fifo.fifo\[13\]\[4\]
+ sky130_fd_sc_hd__edfxtp_1
XTAP_691 VGND VPWR sky130_fd_sc_hd__tapvpwrvgnd_1
XTAP_680 VGND VPWR sky130_fd_sc_hd__tapvpwrvgnd_1
XFILLER_0_54_363 VGND VGND VPWR VPWR sky130_fd_sc_hd__fill_1
XFILLER_0_14_205 VGND VGND VPWR VPWR sky130_fd_sc_hd__decap_3
X_2722_ clknet_leaf_39_clk _0412_ _0014_ VGND VGND VPWR VPWR tx_fifo.fifo\[11\]\[7\]
+ sky130_fd_sc_hd__edfxtp_1
X_1604_ rx_fifo.fifo\[6\]\[1\] _0530_ net168 rx_fifo.fifo\[1\]\[1\] net165 rx_fifo.fifo\[12\]\[1\]
+ VGND VGND VPWR VPWR _0808_ sky130_fd_sc_hd__a222oi_1
X_2584_ clknet_leaf_18_clk _0217_ net82 VGND VGND VPWR VPWR rx_fifo.fifo\[12\]\[2\]
+ sky130_fd_sc_hd__edfxtp_1
X_1535_ rx_fifo.fifo\[4\]\[5\] net173 net170 rx_fifo.fifo\[14\]\[5\] net163 rx_fifo.fifo\[5\]\[5\]
+ VGND VGND VPWR VPWR _0743_ sky130_fd_sc_hd__a222oi_1
X_2653_ clknet_leaf_21_clk _0209_ _0020_ VGND VGND VPWR VPWR rx_fifo.fifo\[13\]\[5\]
+ sky130_fd_sc_hd__edfxtp_1
Xfanout107 net108 VGND VGND VPWR VPWR net107 sky130_fd_sc_hd__clkbuf_4
Xfanout118 _0844_ VGND VGND VPWR VPWR net118 sky130_fd_sc_hd__buf_2
X_1397_ tx.baud_cnt\[12\] tx.baud_cnt\[11\] _0635_ VGND VGND VPWR VPWR _0636_ sky130_fd_sc_hd__and3_1
X_1466_ divisor\[4\] rx.baud_cnt\[0\] _0686_ VGND VGND VPWR VPWR _0687_ sky130_fd_sc_hd__a21oi_1
XFILLER_0_38_83 VGND VGND VPWR VPWR sky130_fd_sc_hd__fill_1
XFILLER_0_54_82 VGND VGND VPWR VPWR sky130_fd_sc_hd__fill_2
XFILLER_0_49_113 VGND VGND VPWR VPWR sky130_fd_sc_hd__fill_2
X_2018_ net220 _0936_ VGND VGND VPWR VPWR _0041_ sky130_fd_sc_hd__nor2_1
XFILLER_0_9_210 VPWR VGND VPWR VGND sky130_ef_sc_hd__decap_12
XFILLER_0_70_81 VGND VGND VPWR VPWR sky130_fd_sc_hd__decap_3
XFILLER_0_60_377 VPWR VGND VPWR VGND sky130_ef_sc_hd__decap_12
XFILLER_0_60_333 VGND VGND VPWR VPWR sky130_fd_sc_hd__decap_4
XFILLER_0_20_208 VGND VGND VPWR VPWR sky130_fd_sc_hd__fill_2
XFILLER_0_70_119 VGND VGND VPWR VPWR sky130_fd_sc_hd__fill_1
XFILLER_0_36_363 VGND VGND VPWR VPWR sky130_fd_sc_hd__fill_1
XFILLER_0_63_193 VPWR VGND VPWR VGND sky130_ef_sc_hd__decap_12
XFILLER_0_59_49 VGND VGND VPWR VPWR sky130_fd_sc_hd__decap_6
XFILLER_0_59_27 VGND VGND VPWR VPWR sky130_fd_sc_hd__decap_6
X_1320_ rx_fifo.fifo\[1\]\[8\] net168 net166 rx_fifo.fifo\[2\]\[8\] VGND VGND VPWR
+ VPWR _0560_ sky130_fd_sc_hd__a22o_1
XFILLER_0_11_219 VGND VGND VPWR VPWR sky130_fd_sc_hd__decap_4
XFILLER_0_75_15 VPWR VGND VPWR VGND sky130_ef_sc_hd__decap_12
XFILLER_0_24_85 VGND VGND VPWR VPWR sky130_fd_sc_hd__fill_2
X_2636_ clknet_leaf_16_clk _0292_ net99 VGND VGND VPWR VPWR rx_fifo.fifo\[5\]\[10\]
+ sky130_fd_sc_hd__edfxtp_1
XFILLER_0_27_330 VGND VGND VPWR VPWR sky130_fd_sc_hd__fill_1
X_2705_ clknet_leaf_34_clk _0127_ net257 VGND VGND VPWR VPWR rx.sample_cnt\[2\] sky130_fd_sc_hd__dfrtp_1
XFILLER_0_6_257 VGND VGND VPWR VPWR sky130_fd_sc_hd__fill_1
XFILLER_0_57_3 VGND VGND VPWR VPWR sky130_fd_sc_hd__decap_8
X_1449_ _0578_ _0668_ rx.baud_cnt\[9\] VGND VGND VPWR VPWR _0670_ sky130_fd_sc_hd__a21oi_1
XFILLER_0_49_82 VGND VGND VPWR VPWR sky130_fd_sc_hd__fill_2
X_1518_ net2 net1 net3 VGND VGND VPWR VPWR _0727_ sky130_fd_sc_hd__and3b_1
X_2567_ clknet_leaf_27_clk _0343_ net85 VGND VGND VPWR VPWR rx_fifo.fifo\[1\]\[7\]
+ sky130_fd_sc_hd__edfxtp_1
X_2498_ _0982_ _0985_ _1239_ VGND VGND VPWR VPWR _0147_ sky130_fd_sc_hd__nand3_1
XFILLER_0_65_447 VGND VGND VPWR VPWR sky130_fd_sc_hd__fill_1
XFILLER_0_18_330 VGND VGND VPWR VPWR sky130_fd_sc_hd__decap_8
XFILLER_0_18_385 VPWR VGND VPWR VGND sky130_ef_sc_hd__decap_12
XFILLER_0_68_230 VPWR VGND VPWR VGND sky130_ef_sc_hd__decap_12
XFILLER_0_56_436 VGND VGND VPWR VPWR sky130_fd_sc_hd__fill_2
Xmax_cap7 _0997_ VGND VGND VPWR VPWR net386 sky130_fd_sc_hd__clkbuf_2
XFILLER_0_71_428 VPWR VGND VPWR VGND sky130_ef_sc_hd__decap_12
XFILLER_0_51_141 VGND VGND VPWR VPWR sky130_fd_sc_hd__fill_2
X_2421_ net146 net91 VGND VGND VPWR VPWR _0336_ sky130_fd_sc_hd__nor2_1
X_1303_ rx_fifo.fifo\[12\]\[10\] net165 net163 rx_fifo.fifo\[5\]\[10\] rx_fifo.fifo\[0\]\[10\]
+ net215 VGND VGND VPWR VPWR _0545_ sky130_fd_sc_hd__a222oi_1
X_2283_ net235 _1125_ _0874_ VGND VGND VPWR VPWR _0160_ sky130_fd_sc_hd__nor3b_2
X_2352_ net218 _0889_ net58 VGND VGND VPWR VPWR _0015_ sky130_fd_sc_hd__nor3_2
XFILLER_0_10_65 VPWR VGND VPWR VGND sky130_ef_sc_hd__decap_12
XFILLER_0_19_41 VGND VGND VPWR VPWR sky130_fd_sc_hd__fill_1
XFILLER_0_29_7 VGND VGND VPWR VPWR sky130_fd_sc_hd__decap_6
XFILLER_0_74_244 VGND VGND VPWR VPWR sky130_fd_sc_hd__fill_1
XFILLER_0_51_94 VPWR VGND VPWR VGND sky130_ef_sc_hd__decap_12
XFILLER_0_47_436 VGND VGND VPWR VPWR sky130_fd_sc_hd__fill_2
XFILLER_0_34_108 VPWR VGND VPWR VGND sky130_ef_sc_hd__decap_12
XFILLER_0_19_105 VGND VGND VPWR VPWR sky130_fd_sc_hd__decap_6
X_2619_ clknet_leaf_14_clk _0186_ net100 VGND VGND VPWR VPWR rx_fifo.fifo\[15\]\[4\]
+ sky130_fd_sc_hd__edfxtp_1
XFILLER_0_42_185 VGND VGND VPWR VPWR sky130_fd_sc_hd__fill_1
XFILLER_0_2_260 VGND VGND VPWR VPWR sky130_fd_sc_hd__decap_4
X_1998_ _0918_ _0919_ VGND VGND VPWR VPWR _0920_ sky130_fd_sc_hd__nor2_1
XFILLER_0_38_436 VGND VGND VPWR VPWR sky130_fd_sc_hd__fill_1
XFILLER_0_65_266 VGND VGND VPWR VPWR sky130_fd_sc_hd__decap_6
Xwire135 _0550_ VGND VGND VPWR VPWR net135 sky130_fd_sc_hd__buf_1
XTAP_509 VGND VPWR sky130_fd_sc_hd__tapvpwrvgnd_1
XFILLER_0_72_27 VGND VGND VPWR VPWR sky130_fd_sc_hd__fill_1
Xload_slew10 _0864_ VGND VGND VPWR VPWR net389 sky130_fd_sc_hd__clkbuf_2
XFILLER_0_71_225 VPWR VGND VPWR VGND sky130_ef_sc_hd__decap_12
X_2970_ clknet_leaf_10_clk _0172_ net244 VGND VGND VPWR VPWR rx.baud_cnt\[5\] sky130_fd_sc_hd__dfrtp_1
XFILLER_0_44_417 VGND VGND VPWR VPWR sky130_fd_sc_hd__decap_3
XFILLER_0_29_447 VGND VGND VPWR VPWR sky130_fd_sc_hd__fill_1
X_1921_ net65 _0900_ VGND VGND VPWR VPWR _0439_ sky130_fd_sc_hd__nor2_1
X_1852_ _0879_ net62 VGND VGND VPWR VPWR _0374_ sky130_fd_sc_hd__nor2_1
X_1783_ net111 net149 VGND VGND VPWR VPWR _0308_ sky130_fd_sc_hd__nor2_1
XFILLER_0_24_141 VGND VGND VPWR VPWR sky130_fd_sc_hd__decap_8
X_2266_ net7 net357 net183 VGND VGND VPWR VPWR _0093_ sky130_fd_sc_hd__mux2_1
X_2404_ net124 net156 net180 VGND VGND VPWR VPWR _0030_ sky130_fd_sc_hd__nor3_2
X_2335_ net77 _1162_ _1163_ _1161_ VGND VGND VPWR VPWR _0129_ sky130_fd_sc_hd__o31ai_1
XFILLER_0_62_71 VGND VGND VPWR VPWR sky130_fd_sc_hd__fill_1
XFILLER_0_47_200 VGND VGND VPWR VPWR sky130_fd_sc_hd__decap_6
XFILLER_0_46_83 VGND VGND VPWR VPWR sky130_fd_sc_hd__fill_1
X_2197_ _0517_ _1084_ VGND VGND VPWR VPWR _1086_ sky130_fd_sc_hd__nor2_1
XFILLER_0_62_203 VGND VGND VPWR VPWR sky130_fd_sc_hd__fill_1
XFILLER_0_47_233 VGND VGND VPWR VPWR sky130_fd_sc_hd__fill_1
XFILLER_0_7_385 VGND VGND VPWR VPWR sky130_fd_sc_hd__decap_6
Xhold98 rx.baud_cnt\[4\] VGND VGND VPWR VPWR net359 sky130_fd_sc_hd__dlygate4sd3_1
Xhold65 _0083_ VGND VGND VPWR VPWR net326 sky130_fd_sc_hd__dlygate4sd3_1
Xhold32 _0166_ VGND VGND VPWR VPWR net293 sky130_fd_sc_hd__dlygate4sd3_1
Xhold10 tx_fifo.tail\[0\] VGND VGND VPWR VPWR net271 sky130_fd_sc_hd__dlygate4sd3_1
Xhold21 _0053_ VGND VGND VPWR VPWR net282 sky130_fd_sc_hd__dlygate4sd3_1
Xhold43 regs.rx_data\[7\] VGND VGND VPWR VPWR net304 sky130_fd_sc_hd__dlygate4sd3_1
Xhold87 _0047_ VGND VGND VPWR VPWR net348 sky130_fd_sc_hd__dlygate4sd3_1
Xhold76 _0043_ VGND VGND VPWR VPWR net337 sky130_fd_sc_hd__dlygate4sd3_1
Xhold54 _0054_ VGND VGND VPWR VPWR net315 sky130_fd_sc_hd__dlygate4sd3_1
XFILLER_0_38_277 VGND VGND VPWR VPWR sky130_fd_sc_hd__decap_6
XFILLER_0_53_225 VGND VGND VPWR VPWR sky130_fd_sc_hd__decap_8
XANTENNA_7 net220 VGND VGND VPWR VPWR sky130_fd_sc_hd__diode_2
XFILLER_0_34_461 VGND VGND VPWR VPWR sky130_fd_sc_hd__fill_2
XFILLER_0_21_111 VGND VGND VPWR VPWR sky130_fd_sc_hd__fill_1
XTAP_339 VGND VPWR sky130_fd_sc_hd__tapvpwrvgnd_1
X_2120_ net34 net75 _1018_ VGND VGND VPWR VPWR _1019_ sky130_fd_sc_hd__nor3_1
XTAP_306 VGND VPWR sky130_fd_sc_hd__tapvpwrvgnd_1
XTAP_317 VGND VPWR sky130_fd_sc_hd__tapvpwrvgnd_1
XTAP_328 VGND VPWR sky130_fd_sc_hd__tapvpwrvgnd_1
XFILLER_0_29_222 VGND VGND VPWR VPWR sky130_fd_sc_hd__fill_2
X_2051_ _0938_ _0944_ VGND VGND VPWR VPWR _0967_ sky130_fd_sc_hd__nand2_4
XFILLER_0_16_53 VGND VGND VPWR VPWR sky130_fd_sc_hd__decap_8
X_2884_ clknet_leaf_9_clk _0085_ net245 VGND VGND VPWR VPWR divisor\[8\] sky130_fd_sc_hd__dfrtp_4
XFILLER_0_44_225 VPWR VGND VPWR VGND sky130_ef_sc_hd__decap_12
XFILLER_0_32_85 VGND VGND VPWR VPWR sky130_fd_sc_hd__decap_4
XFILLER_0_32_74 VGND VGND VPWR VPWR sky130_fd_sc_hd__decap_8
XFILLER_0_32_41 VGND VGND VPWR VPWR sky130_fd_sc_hd__fill_1
X_1835_ tx.tx_busy net121 VGND VGND VPWR VPWR _0875_ sky130_fd_sc_hd__nor2_2
X_2953_ clknet_leaf_1_clk _0032_ net240 VGND VGND VPWR VPWR tx_fifo.tail\[2\] sky130_fd_sc_hd__dfrtp_4
X_1904_ net65 _0897_ VGND VGND VPWR VPWR _0423_ sky130_fd_sc_hd__nor2_1
X_1697_ net103 _0858_ VGND VGND VPWR VPWR _0216_ sky130_fd_sc_hd__nor2_1
X_1766_ net101 _0866_ VGND VGND VPWR VPWR _0280_ sky130_fd_sc_hd__nor2_1
X_2249_ net327 divisor\[13\] net182 VGND VGND VPWR VPWR _0080_ sky130_fd_sc_hd__mux2_1
X_2318_ rx.state\[1\] net232 VGND VGND VPWR VPWR _1149_ sky130_fd_sc_hd__nand2_1
XFILLER_0_35_225 VGND VGND VPWR VPWR sky130_fd_sc_hd__fill_2
XFILLER_0_7_160 VGND VGND VPWR VPWR sky130_fd_sc_hd__fill_1
Xoutput22 net22 VGND VGND VPWR VPWR out2 sky130_fd_sc_hd__clkbuf_4
Xoutput33 net33 VGND VGND VPWR VPWR temt sky130_fd_sc_hd__clkbuf_4
XFILLER_0_9_3 VGND VGND VPWR VPWR sky130_fd_sc_hd__decap_6
XPHY_150 VGND VGND VPWR VPWR sky130_fd_sc_hd__decap_3
XFILLER_0_41_206 VPWR VGND VPWR VGND sky130_ef_sc_hd__decap_12
XFILLER_0_26_247 VGND VGND VPWR VPWR sky130_fd_sc_hd__fill_2
X_1551_ rx_fifo.fifo\[13\]\[4\] net175 net168 rx_fifo.fifo\[1\]\[4\] net163 rx_fifo.fifo\[5\]\[4\]
+ VGND VGND VPWR VPWR _0758_ sky130_fd_sc_hd__a222oi_1
X_1482_ _0658_ net74 _0702_ VGND VGND VPWR VPWR _0163_ sky130_fd_sc_hd__nor3_1
X_1620_ net211 _0821_ VGND VGND VPWR VPWR _0822_ sky130_fd_sc_hd__nand2_1
XFILLER_0_22_453 VGND VGND VPWR VPWR sky130_fd_sc_hd__fill_2
XFILLER_0_27_96 VGND VGND VPWR VPWR sky130_fd_sc_hd__fill_1
XFILLER_0_27_52 VGND VGND VPWR VPWR sky130_fd_sc_hd__decap_4
X_2103_ net229 net231 net227 net225 VGND VGND VPWR VPWR _1002_ sky130_fd_sc_hd__nor4b_4
XTAP_169 VGND VPWR sky130_fd_sc_hd__tapvpwrvgnd_1
XTAP_158 VGND VPWR sky130_fd_sc_hd__tapvpwrvgnd_1
XFILLER_0_64_309 VGND VGND VPWR VPWR sky130_fd_sc_hd__decap_6
XFILLER_0_43_95 VPWR VGND VPWR VGND sky130_ef_sc_hd__decap_12
X_2034_ net6 net35 loopback_en VGND VGND VPWR VPWR _0952_ sky130_fd_sc_hd__mux2i_4
X_1818_ net110 net146 VGND VGND VPWR VPWR _0340_ sky130_fd_sc_hd__nor2_1
XFILLER_0_57_383 VGND VGND VPWR VPWR sky130_fd_sc_hd__decap_8
X_2867_ clknet_leaf_27_clk net319 net255 VGND VGND VPWR VPWR regs.oe sky130_fd_sc_hd__dfrtp_2
X_2798_ clknet_leaf_0_clk _0392_ net40 VGND VGND VPWR VPWR tx_fifo.fifo\[13\]\[3\]
+ sky130_fd_sc_hd__edfxtp_1
X_2936_ clknet_leaf_32_clk _0045_ net258 VGND VGND VPWR VPWR rx.shift_reg\[5\] sky130_fd_sc_hd__dfrtp_1
XFILLER_0_17_225 VPWR VGND VPWR VGND sky130_ef_sc_hd__decap_12
XTAP_670 VGND VPWR sky130_fd_sc_hd__tapvpwrvgnd_1
X_1749_ net114 _0865_ VGND VGND VPWR VPWR _0276_ sky130_fd_sc_hd__nor2_1
XFILLER_0_40_250 VGND VGND VPWR VPWR sky130_fd_sc_hd__fill_2
XTAP_692 VGND VPWR sky130_fd_sc_hd__tapvpwrvgnd_1
XTAP_681 VGND VPWR sky130_fd_sc_hd__tapvpwrvgnd_1
XFILLER_0_67_169 VGND VGND VPWR VPWR sky130_fd_sc_hd__decap_4
XFILLER_0_48_29 VGND VGND VPWR VPWR sky130_fd_sc_hd__decap_3
X_2652_ clknet_leaf_20_clk _0208_ net97 VGND VGND VPWR VPWR rx_fifo.fifo\[13\]\[4\]
+ sky130_fd_sc_hd__edfxtp_1
X_2721_ clknet_leaf_42_clk _0411_ net50 VGND VGND VPWR VPWR tx_fifo.fifo\[11\]\[6\]
+ sky130_fd_sc_hd__edfxtp_1
X_2583_ clknet_leaf_19_clk _0216_ net82 VGND VGND VPWR VPWR rx_fifo.fifo\[12\]\[1\]
+ sky130_fd_sc_hd__edfxtp_1
X_1603_ rx_fifo.fifo\[3\]\[1\] net176 _0527_ rx_fifo.fifo\[11\]\[1\] net166 rx_fifo.fifo\[2\]\[1\]
+ VGND VGND VPWR VPWR _0807_ sky130_fd_sc_hd__a222oi_1
Xfanout119 net120 VGND VGND VPWR VPWR net119 sky130_fd_sc_hd__clkbuf_4
X_1465_ rx.baud_cnt\[12\] rx.baud_cnt\[14\] rx.baud_cnt\[15\] rx.baud_cnt\[13\] VGND
+ VGND VPWR VPWR _0686_ sky130_fd_sc_hd__or4_1
X_1534_ rx_fifo.fifo\[2\]\[5\] net166 net162 rx_fifo.fifo\[8\]\[5\] rx_fifo.fifo\[10\]\[5\]
+ net167 VGND VGND VPWR VPWR _0742_ sky130_fd_sc_hd__a222oi_1
Xfanout108 _0849_ VGND VGND VPWR VPWR net108 sky130_fd_sc_hd__clkbuf_4
XFILLER_0_1_111 VGND VGND VPWR VPWR sky130_fd_sc_hd__fill_1
XFILLER_0_10_401 VGND VGND VPWR VPWR sky130_fd_sc_hd__decap_8
X_1396_ tx.baud_cnt\[10\] tx.baud_cnt\[9\] tx.baud_cnt\[8\] _0633_ VGND VGND VPWR
+ VPWR _0635_ sky130_fd_sc_hd__and4_1
X_2017_ tx_fifo.count\[0\] _0920_ VGND VGND VPWR VPWR _0936_ sky130_fd_sc_hd__xor2_1
XFILLER_0_64_128 VPWR VGND VPWR VGND sky130_ef_sc_hd__decap_12
XFILLER_0_49_169 VGND VGND VPWR VPWR sky130_fd_sc_hd__fill_2
XFILLER_0_9_222 VGND VGND VPWR VPWR sky130_fd_sc_hd__fill_2
XFILLER_0_9_277 VGND VGND VPWR VPWR sky130_fd_sc_hd__decap_3
X_2919_ clknet_leaf_33_clk _0145_ net257 VGND VGND VPWR VPWR rx.parity_err_lat sky130_fd_sc_hd__dfrtp_1
XFILLER_0_60_389 VGND VGND VPWR VPWR sky130_fd_sc_hd__fill_1
XFILLER_0_68_456 VGND VGND VPWR VPWR sky130_fd_sc_hd__decap_6
XFILLER_0_50_19 VGND VGND VPWR VPWR sky130_fd_sc_hd__fill_1
XFILLER_0_75_27 VPWR VGND VPWR VGND sky130_ef_sc_hd__decap_12
XFILLER_0_51_389 VGND VGND VPWR VPWR sky130_fd_sc_hd__decap_3
XFILLER_0_59_445 VGND VGND VPWR VPWR sky130_fd_sc_hd__decap_3
XFILLER_0_6_203 VGND VGND VPWR VPWR sky130_fd_sc_hd__decap_4
X_2635_ clknet_leaf_18_clk _0301_ _0022_ VGND VGND VPWR VPWR rx_fifo.fifo\[5\]\[9\]
+ sky130_fd_sc_hd__edfxtp_1
XFILLER_0_40_41 VPWR VGND VPWR VGND sky130_ef_sc_hd__decap_12
X_2704_ clknet_leaf_33_clk _0128_ net257 VGND VGND VPWR VPWR rx.sample_cnt\[1\] sky130_fd_sc_hd__dfrtp_2
X_1448_ rx.baud_cnt\[9\] _0578_ _0668_ VGND VGND VPWR VPWR _0669_ sky130_fd_sc_hd__and3_1
X_2566_ clknet_leaf_26_clk _0342_ net85 VGND VGND VPWR VPWR rx_fifo.fifo\[1\]\[6\]
+ sky130_fd_sc_hd__edfxtp_1
X_1517_ _0715_ _0725_ _0714_ VGND VGND VPWR VPWR _0726_ sky130_fd_sc_hd__a21oi_1
XFILLER_0_4_85 VPWR VGND VPWR VGND sky130_ef_sc_hd__decap_12
X_2497_ _0976_ _0977_ net232 VGND VGND VPWR VPWR _1239_ sky130_fd_sc_hd__o21ai_0
XFILLER_0_77_253 VPWR VGND VPWR VGND sky130_ef_sc_hd__decap_12
X_1379_ tx.baud_cnt\[5\] _0600_ VGND VGND VPWR VPWR _0618_ sky130_fd_sc_hd__xor2_1
XFILLER_0_65_82 VGND VGND VPWR VPWR sky130_fd_sc_hd__fill_1
XFILLER_0_37_106 VGND VGND VPWR VPWR sky130_fd_sc_hd__decap_6
XFILLER_0_60_131 VGND VGND VPWR VPWR sky130_fd_sc_hd__fill_1
XFILLER_0_18_353 VGND VGND VPWR VPWR sky130_fd_sc_hd__fill_2
XFILLER_0_18_397 VGND VGND VPWR VPWR sky130_fd_sc_hd__decap_4
Xmax_cap8 _0994_ VGND VGND VPWR VPWR net387 sky130_fd_sc_hd__buf_1
XFILLER_0_68_253 VPWR VGND VPWR VGND sky130_ef_sc_hd__decap_12
XFILLER_0_68_242 VGND VGND VPWR VPWR sky130_fd_sc_hd__fill_1
X_2420_ net147 net91 VGND VGND VPWR VPWR _0325_ sky130_fd_sc_hd__nor2_1
Xfanout90 _1191_ VGND VGND VPWR VPWR net90 sky130_fd_sc_hd__clkbuf_4
XFILLER_0_36_150 VGND VGND VPWR VPWR sky130_fd_sc_hd__decap_8
XFILLER_0_3_228 VGND VGND VPWR VPWR sky130_fd_sc_hd__decap_6
XFILLER_0_10_77 VGND VGND VPWR VPWR sky130_fd_sc_hd__decap_6
X_1302_ rx_fifo.fifo\[11\]\[10\] net171 net167 rx_fifo.fifo\[10\]\[10\] rx_fifo.fifo\[4\]\[10\]
+ net173 VGND VGND VPWR VPWR _0544_ sky130_fd_sc_hd__a222oi_1
X_2282_ net7 data_bits\[0\] _1133_ VGND VGND VPWR VPWR _0107_ sky130_fd_sc_hd__mux2_1
X_2351_ net240 net76 VGND VGND VPWR VPWR _1166_ sky130_fd_sc_hd__nand2_1
XFILLER_0_47_404 VPWR VGND VPWR VGND sky130_ef_sc_hd__decap_12
XFILLER_0_35_63 VGND VGND VPWR VPWR sky130_fd_sc_hd__fill_1
XFILLER_0_74_256 VGND VGND VPWR VPWR sky130_fd_sc_hd__decap_8
X_1997_ _0877_ _0912_ VGND VGND VPWR VPWR _0919_ sky130_fd_sc_hd__nor2_2
X_2618_ clknet_leaf_22_clk _0185_ net100 VGND VGND VPWR VPWR rx_fifo.fifo\[15\]\[3\]
+ sky130_fd_sc_hd__edfxtp_1
X_2549_ clknet_leaf_16_clk _0346_ net88 VGND VGND VPWR VPWR rx_fifo.fifo\[0\]\[0\]
+ sky130_fd_sc_hd__edfxtp_1
XFILLER_0_42_197 VGND VGND VPWR VPWR sky130_fd_sc_hd__fill_1
Xwire136 _0548_ VGND VGND VPWR VPWR net136 sky130_fd_sc_hd__buf_1
XFILLER_0_65_289 VGND VGND VPWR VPWR sky130_fd_sc_hd__decap_3
XFILLER_0_25_109 VGND VGND VPWR VPWR sky130_fd_sc_hd__decap_3
XFILLER_0_0_209 VPWR VGND VPWR VGND sky130_ef_sc_hd__decap_12
XFILLER_0_56_29 VGND VGND VPWR VPWR sky130_fd_sc_hd__decap_3
XFILLER_0_71_237 VGND VGND VPWR VPWR sky130_fd_sc_hd__decap_4
X_1851_ regs.tx_data\[1\] _0876_ VGND VGND VPWR VPWR _0886_ sky130_fd_sc_hd__nand2_1
X_1920_ net67 _0900_ VGND VGND VPWR VPWR _0440_ sky130_fd_sc_hd__nor2_1
XFILLER_0_8_309 VGND VGND VPWR VPWR sky130_fd_sc_hd__decap_8
X_1782_ net114 net149 VGND VGND VPWR VPWR _0309_ sky130_fd_sc_hd__nor2_1
X_2403_ net157 net90 VGND VGND VPWR VPWR _0215_ sky130_fd_sc_hd__nor2_1
XFILLER_0_24_197 VGND VGND VPWR VPWR sky130_fd_sc_hd__decap_3
XFILLER_0_12_348 VGND VGND VPWR VPWR sky130_fd_sc_hd__fill_1
X_2265_ net8 net355 net183 VGND VGND VPWR VPWR _0092_ sky130_fd_sc_hd__mux2_1
X_2196_ rx_fifo.head\[0\] regs.rx_fifo_pop net17 VGND VGND VPWR VPWR _1085_ sky130_fd_sc_hd__and3_1
X_2334_ rx.sample_cnt\[0\] _0953_ VGND VGND VPWR VPWR _1163_ sky130_fd_sc_hd__lpflow_isobufsrc_1
XFILLER_0_62_83 VGND VGND VPWR VPWR sky130_fd_sc_hd__fill_1
XFILLER_0_1_31 VGND VGND VPWR VPWR sky130_fd_sc_hd__fill_1
XFILLER_0_62_237 VPWR VGND VPWR VGND sky130_ef_sc_hd__decap_12
XFILLER_0_7_342 VGND VGND VPWR VPWR sky130_fd_sc_hd__decap_6
XFILLER_0_7_353 VPWR VGND VPWR VGND sky130_ef_sc_hd__decap_12
XFILLER_0_15_175 VGND VGND VPWR VPWR sky130_fd_sc_hd__fill_1
Xhold22 rx.baud_cnt\[0\] VGND VGND VPWR VPWR net283 sky130_fd_sc_hd__dlygate4sd3_1
Xhold11 rx.bit_cnt\[2\] VGND VGND VPWR VPWR net272 sky130_fd_sc_hd__dlygate4sd3_1
Xhold99 rx.baud_cnt\[9\] VGND VGND VPWR VPWR net360 sky130_fd_sc_hd__dlygate4sd3_1
Xhold88 regs.ier\[1\] VGND VGND VPWR VPWR net349 sky130_fd_sc_hd__dlygate4sd3_1
Xhold77 rx.baud_cnt\[15\] VGND VGND VPWR VPWR net338 sky130_fd_sc_hd__dlygate4sd3_1
Xhold66 regs.dlh\[5\] VGND VGND VPWR VPWR net327 sky130_fd_sc_hd__dlygate4sd3_1
Xhold55 rx_fifo.count\[4\] VGND VGND VPWR VPWR net316 sky130_fd_sc_hd__buf_1
Xhold33 tx.shift_reg\[5\] VGND VGND VPWR VPWR net294 sky130_fd_sc_hd__dlygate4sd3_1
Xhold44 _0146_ VGND VGND VPWR VPWR net305 sky130_fd_sc_hd__dlygate4sd3_1
XFILLER_0_53_237 VGND VGND VPWR VPWR sky130_fd_sc_hd__decap_4
XFILLER_0_61_281 VPWR VGND VPWR VGND sky130_ef_sc_hd__decap_12
XFILLER_0_21_178 VGND VGND VPWR VPWR sky130_fd_sc_hd__decap_8
XFILLER_0_21_167 VGND VGND VPWR VPWR sky130_fd_sc_hd__fill_1
XTAP_307 VGND VPWR sky130_fd_sc_hd__tapvpwrvgnd_1
X_2050_ net336 _0956_ _0966_ VGND VGND VPWR VPWR _0043_ sky130_fd_sc_hd__a21oi_1
XTAP_318 VGND VPWR sky130_fd_sc_hd__tapvpwrvgnd_1
XTAP_329 VGND VPWR sky130_fd_sc_hd__tapvpwrvgnd_1
XFILLER_0_76_307 VGND VGND VPWR VPWR sky130_fd_sc_hd__fill_1
XFILLER_0_69_381 VGND VGND VPWR VPWR sky130_fd_sc_hd__fill_2
X_2952_ clknet_leaf_1_clk _0033_ net240 VGND VGND VPWR VPWR tx_fifo.tail\[1\] sky130_fd_sc_hd__dfrtp_4
XFILLER_0_16_65 VPWR VGND VPWR VGND sky130_ef_sc_hd__decap_12
X_1765_ net103 _0866_ VGND VGND VPWR VPWR _0282_ sky130_fd_sc_hd__nor2_1
X_2883_ clknet_leaf_12_clk _0086_ net245 VGND VGND VPWR VPWR divisor\[7\] sky130_fd_sc_hd__dfrtp_2
Xmax_cap211 _0732_ VGND VGND VPWR VPWR net211 sky130_fd_sc_hd__clkbuf_2
XFILLER_0_44_237 VPWR VGND VPWR VGND sky130_ef_sc_hd__decap_12
Xmax_cap200 _0899_ VGND VGND VPWR VPWR net200 sky130_fd_sc_hd__buf_1
X_1834_ tx_fifo.count\[4\] net217 VGND VGND VPWR VPWR _0874_ sky130_fd_sc_hd__nand2_2
X_1903_ net66 _0897_ VGND VGND VPWR VPWR _0424_ sky130_fd_sc_hd__nor2_1
XFILLER_0_12_112 VGND VGND VPWR VPWR sky130_fd_sc_hd__decap_4
X_1696_ net105 net157 VGND VGND VPWR VPWR _0217_ sky130_fd_sc_hd__nor2_1
XFILLER_0_12_145 VGND VGND VPWR VPWR sky130_fd_sc_hd__fill_1
X_2248_ _0729_ _1125_ _1127_ VGND VGND VPWR VPWR _0079_ sky130_fd_sc_hd__o21ai_0
XFILLER_0_32_3 VPWR VGND VPWR VGND sky130_ef_sc_hd__decap_12
X_2317_ rx.state\[1\] rx.state\[0\] net232 net77 VGND VGND VPWR VPWR _1148_ sky130_fd_sc_hd__o31ai_1
X_2179_ tx_fifo.fifo\[13\]\[0\] _0999_ net192 tx_fifo.fifo\[9\]\[0\] VGND VGND VPWR
+ VPWR _1072_ sky130_fd_sc_hd__a22oi_1
XFILLER_0_67_329 VGND VGND VPWR VPWR sky130_fd_sc_hd__fill_2
Xoutput23 net23 VGND VGND VPWR VPWR parity_err sky130_fd_sc_hd__clkbuf_4
XFILLER_0_43_281 VPWR VGND VPWR VGND sky130_ef_sc_hd__decap_12
Xoutput34 net34 VGND VGND VPWR VPWR thre sky130_fd_sc_hd__clkbuf_4
XFILLER_0_16_462 VGND VGND VPWR VPWR sky130_fd_sc_hd__fill_1
XPHY_151 VGND VGND VPWR VPWR sky130_fd_sc_hd__decap_3
XPHY_140 VGND VGND VPWR VPWR sky130_fd_sc_hd__decap_3
XFILLER_0_41_218 VGND VGND VPWR VPWR sky130_fd_sc_hd__fill_2
XFILLER_0_5_109 VGND VGND VPWR VPWR sky130_fd_sc_hd__decap_3
X_1481_ rx.baud_cnt\[11\] _0657_ VGND VGND VPWR VPWR _0702_ sky130_fd_sc_hd__nor2_1
X_1550_ rx_fifo.fifo\[8\]\[4\] net162 net161 rx_fifo.fifo\[9\]\[4\] rx_fifo.fifo\[10\]\[4\]
+ net167 VGND VGND VPWR VPWR _0757_ sky130_fd_sc_hd__a222oi_1
XFILLER_0_1_337 VGND VGND VPWR VPWR sky130_fd_sc_hd__decap_6
XFILLER_0_1_315 VPWR VGND VPWR VGND sky130_ef_sc_hd__decap_12
XTAP_159 VGND VPWR sky130_fd_sc_hd__tapvpwrvgnd_1
X_2033_ net77 _0947_ VGND VGND VPWR VPWR _0951_ sky130_fd_sc_hd__nand2_1
X_2102_ net229 net227 net224 net230 VGND VGND VPWR VPWR _1001_ sky130_fd_sc_hd__nor4bb_4
XFILLER_0_72_321 VGND VGND VPWR VPWR sky130_fd_sc_hd__decap_3
XFILLER_0_43_85 VGND VGND VPWR VPWR sky130_fd_sc_hd__fill_1
X_2935_ clknet_leaf_32_clk _0046_ net258 VGND VGND VPWR VPWR rx.shift_reg\[4\] sky130_fd_sc_hd__dfrtp_1
XFILLER_0_17_237 VPWR VGND VPWR VGND sky130_ef_sc_hd__decap_12
X_1817_ net112 net146 VGND VGND VPWR VPWR _0341_ sky130_fd_sc_hd__nor2_1
XFILLER_0_72_365 VPWR VGND VPWR VGND sky130_ef_sc_hd__decap_12
XFILLER_0_72_354 VGND VGND VPWR VPWR sky130_fd_sc_hd__decap_8
X_1748_ net116 _0865_ VGND VGND VPWR VPWR _0277_ sky130_fd_sc_hd__nor2_1
X_2866_ clknet_leaf_6_clk _0156_ net241 VGND VGND VPWR VPWR regs.dlab sky130_fd_sc_hd__dfrtp_1
XFILLER_0_25_281 VGND VGND VPWR VPWR sky130_fd_sc_hd__decap_4
X_2797_ clknet_leaf_1_clk _0391_ net40 VGND VGND VPWR VPWR tx_fifo.fifo\[13\]\[2\]
+ sky130_fd_sc_hd__edfxtp_1
XFILLER_0_4_197 VGND VGND VPWR VPWR sky130_fd_sc_hd__fill_2
XFILLER_0_4_175 VGND VGND VPWR VPWR sky130_fd_sc_hd__fill_1
XTAP_693 VGND VPWR sky130_fd_sc_hd__tapvpwrvgnd_1
XTAP_682 VGND VPWR sky130_fd_sc_hd__tapvpwrvgnd_1
X_1679_ net115 net158 VGND VGND VPWR VPWR _0211_ sky130_fd_sc_hd__nor2_1
XTAP_671 VGND VPWR sky130_fd_sc_hd__tapvpwrvgnd_1
XTAP_660 VGND VPWR sky130_fd_sc_hd__tapvpwrvgnd_1
XFILLER_0_75_181 VPWR VGND VPWR VGND sky130_ef_sc_hd__decap_12
XFILLER_0_63_310 VPWR VGND VPWR VGND sky130_ef_sc_hd__decap_12
XFILLER_0_48_395 VGND VGND VPWR VPWR sky130_fd_sc_hd__fill_1
XFILLER_0_48_351 VGND VGND VPWR VPWR sky130_fd_sc_hd__decap_6
XFILLER_0_16_270 VGND VGND VPWR VPWR sky130_fd_sc_hd__fill_1
XFILLER_0_64_29 VGND VGND VPWR VPWR sky130_fd_sc_hd__fill_2
XFILLER_0_39_362 VGND VGND VPWR VPWR sky130_fd_sc_hd__fill_2
XFILLER_0_6_407 VPWR VGND VPWR VGND sky130_ef_sc_hd__decap_12
X_2582_ clknet_leaf_13_clk _0214_ net82 VGND VGND VPWR VPWR rx_fifo.fifo\[12\]\[0\]
+ sky130_fd_sc_hd__edfxtp_1
X_2651_ clknet_leaf_21_clk _0207_ net97 VGND VGND VPWR VPWR rx_fifo.fifo\[13\]\[3\]
+ sky130_fd_sc_hd__edfxtp_1
X_1602_ rx_fifo.fifo\[13\]\[1\] net175 net161 rx_fifo.fifo\[9\]\[1\] _0805_ VGND VGND
+ VPWR VPWR _0806_ sky130_fd_sc_hd__a221oi_1
X_2720_ clknet_leaf_41_clk _0410_ net50 VGND VGND VPWR VPWR tx_fifo.fifo\[11\]\[5\]
+ sky130_fd_sc_hd__edfxtp_1
X_1395_ tx.baud_cnt\[8\] _0633_ VGND VGND VPWR VPWR _0634_ sky130_fd_sc_hd__nand2_1
X_1464_ divisor\[5\] rx.baud_cnt\[1\] VGND VGND VPWR VPWR _0685_ sky130_fd_sc_hd__xor2_1
Xfanout109 net110 VGND VGND VPWR VPWR net109 sky130_fd_sc_hd__clkbuf_4
XFILLER_0_38_85 VPWR VGND VPWR VGND sky130_ef_sc_hd__decap_12
XFILLER_0_38_41 VPWR VGND VPWR VGND sky130_ef_sc_hd__decap_12
X_1533_ rx_fifo.fifo\[0\]\[5\] net215 net161 rx_fifo.fifo\[9\]\[5\] VGND VGND VPWR
+ VPWR _0741_ sky130_fd_sc_hd__a22oi_1
XFILLER_0_1_167 VGND VGND VPWR VPWR sky130_fd_sc_hd__fill_1
X_2016_ _0932_ _0935_ net220 VGND VGND VPWR VPWR _0040_ sky130_fd_sc_hd__a21oi_1
XFILLER_0_70_61 VGND VGND VPWR VPWR sky130_fd_sc_hd__decap_3
Xclkbuf_leaf_30_clk clknet_2_1__leaf_clk VGND VGND VPWR VPWR clknet_leaf_30_clk sky130_fd_sc_hd__clkbuf_16
X_2918_ clknet_leaf_32_clk _0143_ net257 VGND VGND VPWR VPWR rx.break_int_lat sky130_fd_sc_hd__dfrtp_1
XFILLER_0_9_289 VGND VGND VPWR VPWR sky130_fd_sc_hd__decap_4
XFILLER_0_72_184 VGND VGND VPWR VPWR sky130_fd_sc_hd__fill_1
X_2849_ clknet_leaf_6_clk _0115_ net247 VGND VGND VPWR VPWR regs.mcr_reg\[6\] sky130_fd_sc_hd__dfrtp_1
XTAP_490 VGND VPWR sky130_fd_sc_hd__tapvpwrvgnd_1
XFILLER_0_68_413 VGND VGND VPWR VPWR sky130_fd_sc_hd__decap_3
Xclkbuf_leaf_21_clk clknet_2_3__leaf_clk VGND VGND VPWR VPWR clknet_leaf_21_clk sky130_fd_sc_hd__clkbuf_16
XFILLER_0_51_357 VPWR VGND VPWR VGND sky130_ef_sc_hd__decap_12
XFILLER_0_36_365 VGND VGND VPWR VPWR sky130_fd_sc_hd__decap_4
XFILLER_0_75_39 VPWR VGND VPWR VGND sky130_ef_sc_hd__decap_12
Xclkbuf_leaf_12_clk clknet_2_2__leaf_clk VGND VGND VPWR VPWR clknet_leaf_12_clk sky130_fd_sc_hd__clkbuf_16
XFILLER_0_54_173 VGND VGND VPWR VPWR sky130_fd_sc_hd__decap_3
XFILLER_0_46_107 VGND VGND VPWR VPWR sky130_fd_sc_hd__decap_8
XFILLER_0_39_192 VGND VGND VPWR VPWR sky130_fd_sc_hd__decap_4
XFILLER_0_40_53 VGND VGND VPWR VPWR sky130_fd_sc_hd__decap_4
X_2565_ clknet_leaf_21_clk _0341_ net85 VGND VGND VPWR VPWR rx_fifo.fifo\[1\]\[5\]
+ sky130_fd_sc_hd__edfxtp_1
X_2634_ clknet_leaf_26_clk _0300_ net99 VGND VGND VPWR VPWR rx_fifo.fifo\[5\]\[8\]
+ sky130_fd_sc_hd__edfxtp_1
X_1516_ _0719_ _0724_ _0716_ VGND VGND VPWR VPWR _0725_ sky130_fd_sc_hd__o21ai_2
X_2703_ clknet_leaf_33_clk _0129_ net257 VGND VGND VPWR VPWR rx.sample_cnt\[0\] sky130_fd_sc_hd__dfrtp_2
XFILLER_0_2_421 VPWR VGND VPWR VGND sky130_ef_sc_hd__decap_12
XFILLER_0_10_221 VPWR VGND VPWR VGND sky130_ef_sc_hd__decap_12
X_1378_ tx.baud_cnt\[12\] _0594_ VGND VGND VPWR VPWR _0617_ sky130_fd_sc_hd__xnor2_1
XFILLER_0_65_72 VGND VGND VPWR VPWR sky130_fd_sc_hd__decap_3
X_1447_ divisor\[12\] divisor\[11\] net160 divisor\[13\] VGND VGND VPWR VPWR _0668_
+ sky130_fd_sc_hd__o31ai_1
X_2496_ _0907_ net54 VGND VGND VPWR VPWR _0492_ sky130_fd_sc_hd__nor2_1
XFILLER_0_4_97 VGND VGND VPWR VPWR sky130_fd_sc_hd__decap_8
XFILLER_0_77_265 VGND VGND VPWR VPWR sky130_fd_sc_hd__decap_8
XFILLER_0_77_221 VGND VGND VPWR VPWR sky130_fd_sc_hd__decap_3
XFILLER_0_65_449 VGND VGND VPWR VPWR sky130_fd_sc_hd__decap_8
XFILLER_0_18_343 VGND VGND VPWR VPWR sky130_fd_sc_hd__decap_3
XFILLER_0_71_419 VGND VGND VPWR VPWR sky130_fd_sc_hd__fill_1
XFILLER_0_68_265 VGND VGND VPWR VPWR sky130_fd_sc_hd__decap_4
Xfanout80 _0024_ VGND VGND VPWR VPWR net80 sky130_fd_sc_hd__buf_4
Xfanout91 _1191_ VGND VGND VPWR VPWR net91 sky130_fd_sc_hd__clkbuf_2
XFILLER_0_51_121 VPWR VGND VPWR VGND sky130_ef_sc_hd__decap_12
XFILLER_0_24_346 VPWR VGND VPWR VGND sky130_ef_sc_hd__decap_12
X_1301_ _0539_ _0540_ _0541_ _0542_ VGND VGND VPWR VPWR _0543_ sky130_fd_sc_hd__nand4_1
X_2281_ net8 data_bits\[1\] _1133_ VGND VGND VPWR VPWR _0106_ sky130_fd_sc_hd__mux2_1
X_2350_ net124 _0861_ net180 VGND VGND VPWR VPWR _0016_ sky130_fd_sc_hd__nor3_1
Xclkbuf_leaf_1_clk clknet_2_0__leaf_clk VGND VGND VPWR VPWR clknet_leaf_1_clk sky130_fd_sc_hd__clkbuf_16
XFILLER_0_47_416 VPWR VGND VPWR VGND sky130_ef_sc_hd__decap_12
XFILLER_0_62_419 VGND VGND VPWR VPWR sky130_fd_sc_hd__fill_1
XFILLER_0_47_449 VPWR VGND VPWR VGND sky130_ef_sc_hd__decap_12
XFILLER_0_42_121 VPWR VGND VPWR VGND sky130_ef_sc_hd__decap_12
X_1996_ regs.tx_start _0913_ VGND VGND VPWR VPWR _0918_ sky130_fd_sc_hd__nor2_1
XFILLER_0_15_335 VGND VGND VPWR VPWR sky130_fd_sc_hd__fill_1
XFILLER_0_62_3 VPWR VGND VPWR VGND sky130_ef_sc_hd__decap_12
X_2548_ clknet_leaf_27_clk _0226_ net89 VGND VGND VPWR VPWR rx_fifo.fifo\[11\]\[10\]
+ sky130_fd_sc_hd__edfxtp_1
X_2617_ clknet_leaf_38_clk _0184_ net100 VGND VGND VPWR VPWR rx_fifo.fifo\[15\]\[2\]
+ sky130_fd_sc_hd__edfxtp_1
X_2479_ net10 net280 _1136_ VGND VGND VPWR VPWR _0144_ sky130_fd_sc_hd__mux2_1
XFILLER_0_65_279 VGND VGND VPWR VPWR sky130_fd_sc_hd__fill_1
XFILLER_0_33_165 VGND VGND VPWR VPWR sky130_fd_sc_hd__decap_3
Xwire137 _1077_ VGND VGND VPWR VPWR net137 sky130_fd_sc_hd__buf_1
XFILLER_0_21_305 VGND VGND VPWR VPWR sky130_fd_sc_hd__decap_6
XFILLER_0_72_29 VPWR VGND VPWR VGND sky130_ef_sc_hd__decap_12
XFILLER_0_71_216 VGND VGND VPWR VPWR sky130_fd_sc_hd__fill_1
X_1781_ net116 net149 VGND VGND VPWR VPWR _0310_ sky130_fd_sc_hd__nor2_1
XFILLER_0_37_460 VGND VGND VPWR VPWR sky130_fd_sc_hd__decap_3
X_1850_ _0879_ net64 VGND VGND VPWR VPWR _0375_ sky130_fd_sc_hd__nor2_1
XFILLER_0_21_11 VGND VGND VPWR VPWR sky130_fd_sc_hd__fill_1
X_2402_ _0986_ _1192_ _1195_ VGND VGND VPWR VPWR _0177_ sky130_fd_sc_hd__nor3_1
X_2333_ rx.sample_cnt\[0\] net199 _1153_ VGND VGND VPWR VPWR _1162_ sky130_fd_sc_hd__nor3_1
XFILLER_0_20_371 VGND VGND VPWR VPWR sky130_fd_sc_hd__fill_1
X_2264_ net9 net346 net183 VGND VGND VPWR VPWR _0091_ sky130_fd_sc_hd__mux2_1
XFILLER_0_46_85 VGND VGND VPWR VPWR sky130_fd_sc_hd__decap_3
XFILLER_0_46_52 VPWR VGND VPWR VGND sky130_ef_sc_hd__decap_12
X_2195_ regs.rx_fifo_pop net17 VGND VGND VPWR VPWR _1084_ sky130_fd_sc_hd__nand2_1
XFILLER_0_47_279 VGND VGND VPWR VPWR sky130_fd_sc_hd__fill_1
XFILLER_0_1_65 VGND VGND VPWR VPWR sky130_fd_sc_hd__decap_3
X_1979_ net63 _0908_ VGND VGND VPWR VPWR _0494_ sky130_fd_sc_hd__nor2_1
Xhold12 rx.baud_cnt\[12\] VGND VGND VPWR VPWR net273 sky130_fd_sc_hd__dlygate4sd3_1
Xhold45 regs.lcr\[5\] VGND VGND VPWR VPWR net306 sky130_fd_sc_hd__dlygate4sd3_1
Xhold56 _0135_ VGND VGND VPWR VPWR net317 sky130_fd_sc_hd__dlygate4sd3_1
Xhold23 regs.rx_data\[1\] VGND VGND VPWR VPWR net284 sky130_fd_sc_hd__dlygate4sd3_1
Xhold34 _0061_ VGND VGND VPWR VPWR net295 sky130_fd_sc_hd__dlygate4sd3_1
XFILLER_0_11_382 VGND VGND VPWR VPWR sky130_fd_sc_hd__decap_8
XFILLER_0_11_393 VPWR VGND VPWR VGND sky130_ef_sc_hd__decap_12
Xhold78 divisor\[12\] VGND VGND VPWR VPWR net339 sky130_fd_sc_hd__dlygate4sd3_1
Xhold67 regs.dlh\[7\] VGND VGND VPWR VPWR net328 sky130_fd_sc_hd__dlygate4sd3_1
XFILLER_0_38_213 VPWR VGND VPWR VGND sky130_ef_sc_hd__decap_12
Xhold89 rx.shift_reg\[2\] VGND VGND VPWR VPWR net350 sky130_fd_sc_hd__dlygate4sd3_1
XFILLER_0_34_441 VPWR VGND VPWR VGND sky130_ef_sc_hd__decap_12
XFILLER_0_61_293 VGND VGND VPWR VPWR sky130_fd_sc_hd__decap_8
XTAP_308 VGND VPWR sky130_fd_sc_hd__tapvpwrvgnd_1
XTAP_319 VGND VPWR sky130_fd_sc_hd__tapvpwrvgnd_1
XFILLER_0_69_393 VPWR VGND VPWR VGND sky130_ef_sc_hd__decap_12
X_2951_ clknet_leaf_7_clk _0034_ net241 VGND VGND VPWR VPWR tx_fifo.tail\[0\] sky130_fd_sc_hd__dfrtp_1
XFILLER_0_29_202 VPWR VGND VPWR VGND sky130_ef_sc_hd__decap_12
X_1902_ net68 _0897_ VGND VGND VPWR VPWR _0425_ sky130_fd_sc_hd__nor2_1
XFILLER_0_16_77 VGND VGND VPWR VPWR sky130_fd_sc_hd__decap_6
X_1764_ net105 net151 VGND VGND VPWR VPWR _0283_ sky130_fd_sc_hd__nor2_1
X_1833_ net101 _0873_ VGND VGND VPWR VPWR _0346_ sky130_fd_sc_hd__nor2_1
XFILLER_0_52_271 VPWR VGND VPWR VGND sky130_ef_sc_hd__decap_12
X_2882_ clknet_leaf_7_clk _0087_ net241 VGND VGND VPWR VPWR divisor\[6\] sky130_fd_sc_hd__dfrtp_4
XFILLER_0_44_249 VGND VGND VPWR VPWR sky130_fd_sc_hd__decap_3
XFILLER_0_25_452 VGND VGND VPWR VPWR sky130_fd_sc_hd__decap_3
Xmax_cap212 _0615_ VGND VGND VPWR VPWR net212 sky130_fd_sc_hd__buf_2
Xmax_cap201 net202 VGND VGND VPWR VPWR net201 sky130_fd_sc_hd__buf_1
X_1695_ net108 net157 VGND VGND VPWR VPWR _0218_ sky130_fd_sc_hd__nor2_1
X_2316_ net353 _1143_ _1147_ VGND VGND VPWR VPWR _0126_ sky130_fd_sc_hd__a21o_1
XFILLER_0_73_94 VGND VGND VPWR VPWR sky130_fd_sc_hd__decap_3
X_2247_ divisor\[14\] net182 VGND VGND VPWR VPWR _1127_ sky130_fd_sc_hd__nand2_1
XFILLER_0_25_3 VPWR VGND VPWR VGND sky130_ef_sc_hd__decap_12
X_2178_ tx_fifo.fifo\[7\]\[0\] _0996_ _1005_ tx_fifo.fifo\[11\]\[0\] VGND VGND VPWR
+ VPWR _1071_ sky130_fd_sc_hd__a22o_1
XFILLER_0_35_205 VPWR VGND VPWR VGND sky130_ef_sc_hd__decap_12
XFILLER_0_50_219 VPWR VGND VPWR VGND sky130_ef_sc_hd__decap_12
Xoutput24 net24 VGND VGND VPWR VPWR rdata[0] sky130_fd_sc_hd__clkbuf_4
Xoutput35 net35 VGND VGND VPWR VPWR tx_out sky130_fd_sc_hd__buf_2
XPHY_152 VGND VGND VPWR VPWR sky130_fd_sc_hd__decap_3
XPHY_141 VGND VGND VPWR VPWR sky130_fd_sc_hd__decap_3
XPHY_130 VGND VGND VPWR VPWR sky130_fd_sc_hd__decap_3
XFILLER_0_34_282 VPWR VGND VPWR VGND sky130_ef_sc_hd__decap_12
X_1480_ _0586_ _0700_ VGND VGND VPWR VPWR _0701_ sky130_fd_sc_hd__nand2_1
XFILLER_0_1_327 VGND VGND VPWR VPWR sky130_fd_sc_hd__decap_8
X_2032_ net77 _0946_ _0949_ VGND VGND VPWR VPWR _0950_ sky130_fd_sc_hd__a21o_1
X_2101_ net225 net227 net229 net231 VGND VGND VPWR VPWR _1000_ sky130_fd_sc_hd__nor4bb_1
XFILLER_0_76_127 VPWR VGND VPWR VGND sky130_ef_sc_hd__decap_12
X_2865_ clknet_leaf_6_clk _0101_ net241 VGND VGND VPWR VPWR regs.lcr\[6\] sky130_fd_sc_hd__dfrtp_1
XFILLER_0_9_449 VPWR VGND VPWR VGND sky130_ef_sc_hd__decap_12
X_2934_ clknet_leaf_32_clk net348 net258 VGND VGND VPWR VPWR rx.shift_reg\[3\] sky130_fd_sc_hd__dfrtp_2
XFILLER_0_17_249 VGND VGND VPWR VPWR sky130_fd_sc_hd__fill_1
XFILLER_0_72_377 VGND VGND VPWR VPWR sky130_fd_sc_hd__fill_1
X_1816_ net114 net146 VGND VGND VPWR VPWR _0342_ sky130_fd_sc_hd__nor2_1
X_1678_ net117 net158 VGND VGND VPWR VPWR _0212_ sky130_fd_sc_hd__nor2_1
X_1747_ net117 net152 VGND VGND VPWR VPWR _0278_ sky130_fd_sc_hd__nor2_1
XFILLER_0_25_293 VGND VGND VPWR VPWR sky130_fd_sc_hd__fill_2
X_2796_ clknet_leaf_0_clk _0390_ net40 VGND VGND VPWR VPWR tx_fifo.fifo\[13\]\[1\]
+ sky130_fd_sc_hd__edfxtp_1
XTAP_694 VGND VPWR sky130_fd_sc_hd__tapvpwrvgnd_1
XTAP_683 VGND VPWR sky130_fd_sc_hd__tapvpwrvgnd_1
XTAP_672 VGND VPWR sky130_fd_sc_hd__tapvpwrvgnd_1
XTAP_661 VGND VPWR sky130_fd_sc_hd__tapvpwrvgnd_1
XTAP_650 VGND VPWR sky130_fd_sc_hd__tapvpwrvgnd_1
XFILLER_0_0_393 VPWR VGND VPWR VGND sky130_ef_sc_hd__decap_12
XFILLER_0_67_149 VPWR VGND VPWR VGND sky130_ef_sc_hd__decap_12
XFILLER_0_75_193 VGND VGND VPWR VPWR sky130_fd_sc_hd__decap_4
XFILLER_0_63_322 VPWR VGND VPWR VGND sky130_ef_sc_hd__decap_12
XFILLER_0_54_300 VGND VGND VPWR VPWR sky130_fd_sc_hd__decap_8
XFILLER_0_39_352 VGND VGND VPWR VPWR sky130_fd_sc_hd__decap_6
XFILLER_0_6_419 VGND VGND VPWR VPWR sky130_fd_sc_hd__fill_1
X_1532_ rx_fifo.fifo\[3\]\[5\] net176 net169 rx_fifo.fifo\[6\]\[5\] VGND VGND VPWR
+ VPWR _0740_ sky130_fd_sc_hd__a22oi_1
X_1601_ net129 _0804_ VGND VGND VPWR VPWR _0805_ sky130_fd_sc_hd__nand2_1
X_2581_ clknet_leaf_24_clk _0325_ net83 VGND VGND VPWR VPWR rx_fifo.fifo\[2\]\[10\]
+ sky130_fd_sc_hd__edfxtp_1
X_2650_ clknet_leaf_26_clk _0206_ net97 VGND VGND VPWR VPWR rx_fifo.fifo\[13\]\[2\]
+ sky130_fd_sc_hd__edfxtp_1
XFILLER_0_1_113 VPWR VGND VPWR VGND sky130_ef_sc_hd__decap_12
X_1394_ tx.baud_cnt\[7\] _0632_ VGND VGND VPWR VPWR _0633_ sky130_fd_sc_hd__and2_1
X_1463_ rx.baud_cnt\[2\] net213 _0682_ VGND VGND VPWR VPWR _0684_ sky130_fd_sc_hd__nor3_1
XFILLER_0_38_97 VPWR VGND VPWR VGND sky130_ef_sc_hd__decap_12
XFILLER_0_38_53 VPWR VGND VPWR VGND sky130_ef_sc_hd__decap_12
XFILLER_0_77_447 VGND VGND VPWR VPWR sky130_fd_sc_hd__fill_1
XFILLER_0_54_74 VGND VGND VPWR VPWR sky130_fd_sc_hd__decap_8
XFILLER_0_54_52 VGND VGND VPWR VPWR sky130_fd_sc_hd__fill_2
X_2015_ _0919_ _0933_ _0934_ VGND VGND VPWR VPWR _0935_ sky130_fd_sc_hd__a21oi_1
XFILLER_0_72_163 VGND VGND VPWR VPWR sky130_fd_sc_hd__fill_1
XFILLER_0_64_119 VGND VGND VPWR VPWR sky130_fd_sc_hd__fill_1
XFILLER_0_45_388 VGND VGND VPWR VPWR sky130_fd_sc_hd__decap_4
X_2848_ clknet_leaf_5_clk _0116_ net247 VGND VGND VPWR VPWR regs.mcr_reg\[5\] sky130_fd_sc_hd__dfrtp_1
XFILLER_0_5_441 VGND VGND VPWR VPWR sky130_fd_sc_hd__decap_6
X_2917_ clknet_leaf_34_clk _0139_ net253 VGND VGND VPWR VPWR tx.tx_busy sky130_fd_sc_hd__dfrtp_4
X_2779_ clknet_leaf_3_clk _0453_ _0006_ VGND VGND VPWR VPWR tx_fifo.fifo\[5\]\[0\]
+ sky130_fd_sc_hd__edfxtp_1
XFILLER_0_0_9 VGND VGND VPWR VPWR sky130_fd_sc_hd__fill_2
XFILLER_0_13_274 VGND VGND VPWR VPWR sky130_fd_sc_hd__decap_6
XTAP_491 VGND VPWR sky130_fd_sc_hd__tapvpwrvgnd_1
XTAP_480 VGND VPWR sky130_fd_sc_hd__tapvpwrvgnd_1
XFILLER_0_63_163 VGND VGND VPWR VPWR sky130_fd_sc_hd__decap_4
XFILLER_0_51_369 VPWR VGND VPWR VGND sky130_ef_sc_hd__decap_12
XFILLER_0_51_325 VGND VGND VPWR VPWR sky130_fd_sc_hd__decap_8
XFILLER_0_74_417 VGND VGND VPWR VPWR sky130_fd_sc_hd__decap_3
XFILLER_0_40_65 VPWR VGND VPWR VGND sky130_ef_sc_hd__decap_12
XFILLER_0_40_21 VGND VGND VPWR VPWR sky130_fd_sc_hd__decap_6
X_2702_ clknet_leaf_38_clk _0237_ net92 VGND VGND VPWR VPWR rx_fifo.fifo\[10\]\[10\]
+ sky130_fd_sc_hd__edfxtp_1
X_2564_ clknet_leaf_20_clk _0340_ net85 VGND VGND VPWR VPWR rx_fifo.fifo\[1\]\[4\]
+ sky130_fd_sc_hd__edfxtp_1
X_2633_ clknet_leaf_20_clk _0299_ net99 VGND VGND VPWR VPWR rx_fifo.fifo\[5\]\[7\]
+ sky130_fd_sc_hd__edfxtp_1
X_1515_ _0720_ _0721_ _0722_ net133 VGND VGND VPWR VPWR _0724_ sky130_fd_sc_hd__nand4_1
XFILLER_0_2_433 VPWR VGND VPWR VGND sky130_ef_sc_hd__decap_12
XFILLER_0_10_233 VGND VGND VPWR VPWR sky130_fd_sc_hd__decap_6
XFILLER_0_10_277 VGND VGND VPWR VPWR sky130_fd_sc_hd__decap_4
X_2495_ rx.shift_reg\[7\] net304 _0987_ VGND VGND VPWR VPWR _0146_ sky130_fd_sc_hd__mux2_1
X_1377_ tx.baud_cnt\[15\] _0581_ VGND VGND VPWR VPWR _0616_ sky130_fd_sc_hd__xnor2_1
XFILLER_0_65_95 VPWR VGND VPWR VGND sky130_ef_sc_hd__decap_12
X_1446_ rx.baud_cnt\[11\] _0663_ VGND VGND VPWR VPWR _0667_ sky130_fd_sc_hd__nand2_2
XFILLER_0_4_43 VGND VGND VPWR VPWR sky130_fd_sc_hd__fill_1
XFILLER_0_73_461 VGND VGND VPWR VPWR sky130_fd_sc_hd__fill_2
Xfanout81 _0025_ VGND VGND VPWR VPWR net81 sky130_fd_sc_hd__buf_4
Xfanout92 _0016_ VGND VGND VPWR VPWR net92 sky130_fd_sc_hd__clkbuf_4
XFILLER_0_28_119 VGND VGND VPWR VPWR sky130_fd_sc_hd__fill_1
Xfanout70 _0882_ VGND VGND VPWR VPWR net70 sky130_fd_sc_hd__clkbuf_4
XFILLER_0_51_133 VGND VGND VPWR VPWR sky130_fd_sc_hd__decap_8
XFILLER_0_24_358 VGND VGND VPWR VPWR sky130_fd_sc_hd__decap_6
X_1300_ rx_fifo.fifo\[13\]\[10\] net175 net168 rx_fifo.fifo\[1\]\[10\] VGND VGND VPWR
+ VPWR _0542_ sky130_fd_sc_hd__a22oi_1
X_2280_ net9 regs.lcr\[2\] _1133_ VGND VGND VPWR VPWR _0105_ sky130_fd_sc_hd__mux2_1
XFILLER_0_35_21 VGND VGND VPWR VPWR sky130_fd_sc_hd__fill_1
XFILLER_0_59_233 VPWR VGND VPWR VGND sky130_ef_sc_hd__decap_12
XFILLER_0_47_428 VGND VGND VPWR VPWR sky130_fd_sc_hd__decap_8
XFILLER_0_35_54 VGND VGND VPWR VPWR sky130_fd_sc_hd__fill_2
XFILLER_0_55_461 VGND VGND VPWR VPWR sky130_fd_sc_hd__fill_2
XFILLER_0_42_133 VGND VGND VPWR VPWR sky130_fd_sc_hd__decap_6
X_2616_ clknet_leaf_29_clk _0183_ net100 VGND VGND VPWR VPWR rx_fifo.fifo\[15\]\[1\]
+ sky130_fd_sc_hd__edfxtp_1
X_1995_ net231 _0912_ _0917_ VGND VGND VPWR VPWR _0037_ sky130_fd_sc_hd__o21a_1
XFILLER_0_76_61 VGND VGND VPWR VPWR sky130_fd_sc_hd__fill_2
X_1429_ rx.baud_cnt\[4\] rx.baud_cnt\[3\] _0652_ VGND VGND VPWR VPWR _0653_ sky130_fd_sc_hd__and3_1
X_2478_ net8 net211 _1134_ VGND VGND VPWR VPWR _0157_ sky130_fd_sc_hd__and3_1
X_2547_ clknet_leaf_27_clk _0235_ net89 VGND VGND VPWR VPWR rx_fifo.fifo\[11\]\[9\]
+ sky130_fd_sc_hd__edfxtp_1
XFILLER_0_23_391 VGND VGND VPWR VPWR sky130_fd_sc_hd__fill_1
XFILLER_0_65_225 VPWR VGND VPWR VGND sky130_ef_sc_hd__decap_12
Xwire127 _0830_ VGND VGND VPWR VPWR net127 sky130_fd_sc_hd__buf_1
Xwire138 net139 VGND VGND VPWR VPWR net138 sky130_fd_sc_hd__buf_1
XFILLER_0_18_174 VGND VGND VPWR VPWR sky130_fd_sc_hd__decap_4
XFILLER_0_33_177 VGND VGND VPWR VPWR sky130_fd_sc_hd__decap_3
Xfanout260 net261 VGND VGND VPWR VPWR net260 sky130_fd_sc_hd__clkbuf_4
XFILLER_0_29_439 VGND VGND VPWR VPWR sky130_fd_sc_hd__fill_1
X_1780_ net117 net149 VGND VGND VPWR VPWR _0311_ sky130_fd_sc_hd__nor2_1
XFILLER_0_12_306 VGND VGND VPWR VPWR sky130_fd_sc_hd__fill_2
XFILLER_0_12_317 VGND VGND VPWR VPWR sky130_fd_sc_hd__fill_1
X_2332_ net333 _1150_ VGND VGND VPWR VPWR _1161_ sky130_fd_sc_hd__nand2_1
X_2401_ _1193_ _1194_ net324 VGND VGND VPWR VPWR _1195_ sky130_fd_sc_hd__a21oi_1
X_2263_ net10 net356 net183 VGND VGND VPWR VPWR _0090_ sky130_fd_sc_hd__mux2_1
XFILLER_0_46_97 VGND VGND VPWR VPWR sky130_fd_sc_hd__decap_4
XFILLER_0_46_75 VGND VGND VPWR VPWR sky130_fd_sc_hd__decap_8
XFILLER_0_46_64 VGND VGND VPWR VPWR sky130_fd_sc_hd__fill_2
X_2194_ net233 net126 _1083_ VGND VGND VPWR VPWR _0069_ sky130_fd_sc_hd__o21a_1
XFILLER_0_62_228 VGND VGND VPWR VPWR sky130_fd_sc_hd__decap_6
XFILLER_0_62_85 VGND VGND VPWR VPWR sky130_fd_sc_hd__decap_4
XFILLER_0_47_225 VGND VGND VPWR VPWR sky130_fd_sc_hd__decap_8
XFILLER_0_28_461 VGND VGND VPWR VPWR sky130_fd_sc_hd__fill_2
XFILLER_0_7_333 VGND VGND VPWR VPWR sky130_fd_sc_hd__decap_3
X_1978_ net64 _0908_ VGND VGND VPWR VPWR _0495_ sky130_fd_sc_hd__nor2_1
Xhold13 regs.dlh\[3\] VGND VGND VPWR VPWR net274 sky130_fd_sc_hd__dlygate4sd3_1
Xhold68 _0134_ VGND VGND VPWR VPWR net329 sky130_fd_sc_hd__dlygate4sd3_1
Xhold57 rx.dr VGND VGND VPWR VPWR net318 sky130_fd_sc_hd__dlygate4sd3_1
Xhold24 _0058_ VGND VGND VPWR VPWR net285 sky130_fd_sc_hd__dlygate4sd3_1
Xhold35 tx.shift_reg\[4\] VGND VGND VPWR VPWR net296 sky130_fd_sc_hd__dlygate4sd3_1
Xhold46 tx.parity_bit VGND VGND VPWR VPWR net307 sky130_fd_sc_hd__dlygate4sd3_1
Xhold79 rx.shift_reg\[0\] VGND VGND VPWR VPWR net340 sky130_fd_sc_hd__dlygate4sd3_1
XFILLER_0_38_225 VGND VGND VPWR VPWR sky130_fd_sc_hd__decap_3
XFILLER_0_46_291 VGND VGND VPWR VPWR sky130_fd_sc_hd__fill_1
XFILLER_0_46_280 VGND VGND VPWR VPWR sky130_fd_sc_hd__fill_2
XFILLER_0_34_453 VGND VGND VPWR VPWR sky130_fd_sc_hd__decap_8
XTAP_309 VGND VPWR sky130_fd_sc_hd__tapvpwrvgnd_1
XFILLER_0_16_23 VGND VGND VPWR VPWR sky130_fd_sc_hd__fill_2
XFILLER_0_76_309 VPWR VGND VPWR VGND sky130_ef_sc_hd__decap_12
X_1832_ net103 net145 VGND VGND VPWR VPWR _0348_ sky130_fd_sc_hd__nor2_1
X_2881_ clknet_leaf_6_clk _0088_ net241 VGND VGND VPWR VPWR divisor\[5\] sky130_fd_sc_hd__dfrtp_4
XFILLER_0_32_66 VGND VGND VPWR VPWR sky130_fd_sc_hd__fill_1
XFILLER_0_29_225 VPWR VGND VPWR VGND sky130_ef_sc_hd__decap_12
XFILLER_0_29_214 VGND VGND VPWR VPWR sky130_fd_sc_hd__decap_8
X_2950_ clknet_leaf_37_clk _0151_ net255 VGND VGND VPWR VPWR tx_fifo.head\[3\] sky130_fd_sc_hd__dfrtp_1
X_1901_ net71 _0897_ VGND VGND VPWR VPWR _0426_ sky130_fd_sc_hd__nor2_1
X_1763_ net107 net151 VGND VGND VPWR VPWR _0284_ sky130_fd_sc_hd__nor2_1
X_1694_ net109 net157 VGND VGND VPWR VPWR _0219_ sky130_fd_sc_hd__nor2_1
Xmax_cap213 _0568_ VGND VGND VPWR VPWR net213 sky130_fd_sc_hd__buf_1
XFILLER_0_52_283 VPWR VGND VPWR VGND sky130_ef_sc_hd__decap_12
XFILLER_0_40_456 VGND VGND VPWR VPWR sky130_fd_sc_hd__decap_3
Xmax_cap202 _0899_ VGND VGND VPWR VPWR net202 sky130_fd_sc_hd__clkbuf_2
XFILLER_0_4_347 VGND VGND VPWR VPWR sky130_fd_sc_hd__fill_2
X_2246_ net237 net15 _0713_ VGND VGND VPWR VPWR _1126_ sky130_fd_sc_hd__nand3_1
X_2315_ tx.bit_cnt\[0\] _1144_ VGND VGND VPWR VPWR _1147_ sky130_fd_sc_hd__nor2_1
XFILLER_0_73_51 VGND VGND VPWR VPWR sky130_fd_sc_hd__decap_4
X_2177_ tx_fifo.fifo\[4\]\[0\] _1006_ VGND VGND VPWR VPWR _1070_ sky130_fd_sc_hd__nand2_1
XFILLER_0_75_375 VPWR VGND VPWR VGND sky130_ef_sc_hd__decap_12
XFILLER_0_75_364 VGND VGND VPWR VPWR sky130_fd_sc_hd__decap_8
XFILLER_0_50_209 VGND VGND VPWR VPWR sky130_fd_sc_hd__fill_2
XFILLER_0_35_217 VGND VGND VPWR VPWR sky130_fd_sc_hd__fill_1
Xoutput25 net25 VGND VGND VPWR VPWR rdata[1] sky130_fd_sc_hd__buf_2
XFILLER_0_3_380 VPWR VGND VPWR VGND sky130_ef_sc_hd__decap_12
XPHY_153 VGND VGND VPWR VPWR sky130_fd_sc_hd__decap_3
XPHY_142 VGND VGND VPWR VPWR sky130_fd_sc_hd__decap_3
XPHY_131 VGND VGND VPWR VPWR sky130_fd_sc_hd__decap_3
XPHY_120 VGND VGND VPWR VPWR sky130_fd_sc_hd__decap_3
XFILLER_0_58_309 VGND VGND VPWR VPWR sky130_fd_sc_hd__decap_3
XFILLER_0_34_294 VPWR VGND VPWR VGND sky130_ef_sc_hd__decap_12
XFILLER_0_22_445 VGND VGND VPWR VPWR sky130_fd_sc_hd__decap_8
X_2100_ net228 net230 net224 net226 VGND VGND VPWR VPWR _0999_ sky130_fd_sc_hd__and4b_4
XFILLER_0_76_139 VGND VGND VPWR VPWR sky130_fd_sc_hd__fill_1
XPHY_0 VGND VGND VPWR VPWR sky130_fd_sc_hd__decap_3
X_2031_ _0941_ _0948_ VGND VGND VPWR VPWR _0949_ sky130_fd_sc_hd__nor2_1
X_2864_ clknet_leaf_6_clk _0102_ net247 VGND VGND VPWR VPWR regs.lcr\[5\] sky130_fd_sc_hd__dfrtp_1
X_1815_ net115 net146 VGND VGND VPWR VPWR _0343_ sky130_fd_sc_hd__nor2_1
XFILLER_0_25_261 VPWR VGND VPWR VGND sky130_ef_sc_hd__decap_12
X_2795_ clknet_leaf_0_clk _0389_ _0004_ VGND VGND VPWR VPWR tx_fifo.fifo\[13\]\[0\]
+ sky130_fd_sc_hd__edfxtp_1
X_2933_ clknet_leaf_32_clk _0048_ net258 VGND VGND VPWR VPWR rx.shift_reg\[2\] sky130_fd_sc_hd__dfrtp_1
X_1677_ net119 net158 VGND VGND VPWR VPWR _0213_ sky130_fd_sc_hd__nor2_1
X_1746_ net119 net152 VGND VGND VPWR VPWR _0279_ sky130_fd_sc_hd__nor2_1
XFILLER_0_4_144 VGND VGND VPWR VPWR sky130_fd_sc_hd__decap_6
XTAP_695 VGND VPWR sky130_fd_sc_hd__tapvpwrvgnd_1
XTAP_684 VGND VPWR sky130_fd_sc_hd__tapvpwrvgnd_1
XTAP_673 VGND VPWR sky130_fd_sc_hd__tapvpwrvgnd_1
XTAP_662 VGND VPWR sky130_fd_sc_hd__tapvpwrvgnd_1
XTAP_651 VGND VPWR sky130_fd_sc_hd__tapvpwrvgnd_1
XTAP_640 VGND VPWR sky130_fd_sc_hd__tapvpwrvgnd_1
X_2229_ tx.bit_cnt\[0\] _1110_ regs.lcr\[2\] VGND VGND VPWR VPWR _1111_ sky130_fd_sc_hd__a21boi_0
XFILLER_0_63_334 VGND VGND VPWR VPWR sky130_fd_sc_hd__fill_2
XFILLER_0_7_3 VPWR VGND VPWR VGND sky130_ef_sc_hd__decap_12
XFILLER_0_39_386 VGND VGND VPWR VPWR sky130_fd_sc_hd__decap_6
XFILLER_0_13_57 VGND VGND VPWR VPWR sky130_fd_sc_hd__decap_8
X_1531_ rx_fifo.fifo\[12\]\[5\] net165 VGND VGND VPWR VPWR _0739_ sky130_fd_sc_hd__nand2_1
X_1462_ net213 _0682_ rx.baud_cnt\[2\] VGND VGND VPWR VPWR _0683_ sky130_fd_sc_hd__o21a_1
X_1600_ rx_fifo.fifo\[0\]\[1\] _0522_ net170 rx_fifo.fifo\[14\]\[1\] rx_fifo.fifo\[5\]\[1\]
+ net163 VGND VGND VPWR VPWR _0804_ sky130_fd_sc_hd__a222oi_1
X_2580_ clknet_leaf_23_clk _0334_ net83 VGND VGND VPWR VPWR rx_fifo.fifo\[2\]\[9\]
+ sky130_fd_sc_hd__edfxtp_1
XFILLER_0_22_286 VGND VGND VPWR VPWR sky130_fd_sc_hd__fill_2
XFILLER_0_1_125 VGND VGND VPWR VPWR sky130_fd_sc_hd__fill_2
XFILLER_0_1_169 VGND VGND VPWR VPWR sky130_fd_sc_hd__decap_6
X_1393_ tx.baud_cnt\[6\] tx.baud_cnt\[5\] _0631_ VGND VGND VPWR VPWR _0632_ sky130_fd_sc_hd__and3_1
XFILLER_0_38_65 VPWR VGND VPWR VGND sky130_ef_sc_hd__decap_12
X_2014_ regs.tx_start _0913_ _0933_ VGND VGND VPWR VPWR _0934_ sky130_fd_sc_hd__nor3_1
XFILLER_0_9_225 VGND VGND VPWR VPWR sky130_fd_sc_hd__decap_3
XFILLER_0_72_153 VGND VGND VPWR VPWR sky130_fd_sc_hd__fill_1
XFILLER_0_57_194 VGND VGND VPWR VPWR sky130_fd_sc_hd__decap_6
Xhold110 rx_fifo.head\[3\] VGND VGND VPWR VPWR net371 sky130_fd_sc_hd__dlygate4sd3_1
X_2847_ clknet_leaf_5_clk _0117_ net247 VGND VGND VPWR VPWR loopback_en sky130_fd_sc_hd__dfrtp_4
X_2916_ clknet_leaf_36_clk _0138_ net254 VGND VGND VPWR VPWR tx.shift_reg\[7\] sky130_fd_sc_hd__dfrtp_1
X_2778_ clknet_leaf_39_clk _0380_ net43 VGND VGND VPWR VPWR tx_fifo.fifo\[15\]\[7\]
+ sky130_fd_sc_hd__edfxtp_1
X_1729_ net108 net154 VGND VGND VPWR VPWR _0251_ sky130_fd_sc_hd__nor2_1
XTAP_492 VGND VPWR sky130_fd_sc_hd__tapvpwrvgnd_1
XTAP_481 VGND VPWR sky130_fd_sc_hd__tapvpwrvgnd_1
XTAP_470 VGND VPWR sky130_fd_sc_hd__tapvpwrvgnd_1
XFILLER_0_48_194 VGND VGND VPWR VPWR sky130_fd_sc_hd__fill_2
XFILLER_0_48_183 VGND VGND VPWR VPWR sky130_fd_sc_hd__fill_2
XFILLER_0_54_197 VGND VGND VPWR VPWR sky130_fd_sc_hd__fill_1
X_2632_ clknet_leaf_25_clk _0298_ net99 VGND VGND VPWR VPWR rx_fifo.fifo\[5\]\[6\]
+ sky130_fd_sc_hd__edfxtp_1
XFILLER_0_40_77 VGND VGND VPWR VPWR sky130_fd_sc_hd__fill_1
X_2701_ clknet_leaf_38_clk _0246_ net92 VGND VGND VPWR VPWR rx_fifo.fifo\[10\]\[9\]
+ sky130_fd_sc_hd__edfxtp_1
XFILLER_0_2_401 VPWR VGND VPWR VGND sky130_ef_sc_hd__decap_12
X_2563_ clknet_leaf_21_clk _0339_ net85 VGND VGND VPWR VPWR rx_fifo.fifo\[1\]\[3\]
+ sky130_fd_sc_hd__edfxtp_1
X_1514_ rx_fifo.fifo\[4\]\[6\] net173 net169 rx_fifo.fifo\[6\]\[6\] rx_fifo.fifo\[13\]\[6\]
+ net175 VGND VGND VPWR VPWR _0723_ sky130_fd_sc_hd__a222oi_1
X_1445_ rx.baud_cnt\[10\] _0665_ VGND VGND VPWR VPWR _0666_ sky130_fd_sc_hd__nand2_1
XFILLER_0_2_445 VPWR VGND VPWR VGND sky130_ef_sc_hd__decap_12
X_2494_ _0906_ net54 VGND VGND VPWR VPWR _0484_ sky130_fd_sc_hd__nor2_1
X_1376_ tx.state\[2\] tx.state\[0\] tx.state\[1\] VGND VGND VPWR VPWR _0615_ sky130_fd_sc_hd__nor3_1
XFILLER_0_65_418 VGND VGND VPWR VPWR sky130_fd_sc_hd__decap_4
XFILLER_0_60_145 VPWR VGND VPWR VGND sky130_ef_sc_hd__decap_12
XFILLER_0_45_175 VGND VGND VPWR VPWR sky130_fd_sc_hd__fill_1
XFILLER_0_5_261 VGND VGND VPWR VPWR sky130_fd_sc_hd__fill_2
XFILLER_0_5_294 VGND VGND VPWR VPWR sky130_fd_sc_hd__fill_1
XFILLER_0_56_429 VGND VGND VPWR VPWR sky130_fd_sc_hd__fill_1
XFILLER_0_56_407 VPWR VGND VPWR VGND sky130_ef_sc_hd__decap_12
XFILLER_0_28_109 VGND VGND VPWR VPWR sky130_fd_sc_hd__fill_2
Xfanout82 _0026_ VGND VGND VPWR VPWR net82 sky130_fd_sc_hd__buf_4
Xfanout93 _0017_ VGND VGND VPWR VPWR net93 sky130_fd_sc_hd__buf_4
Xfanout71 _0882_ VGND VGND VPWR VPWR net71 sky130_fd_sc_hd__buf_2
XFILLER_0_24_337 VGND VGND VPWR VPWR sky130_fd_sc_hd__decap_3
Xfanout60 net61 VGND VGND VPWR VPWR net60 sky130_fd_sc_hd__buf_2
XFILLER_0_51_167 VGND VGND VPWR VPWR sky130_fd_sc_hd__fill_1
XFILLER_0_59_245 VPWR VGND VPWR VGND sky130_ef_sc_hd__decap_12
XFILLER_0_59_223 VGND VGND VPWR VPWR sky130_fd_sc_hd__fill_1
X_1994_ net231 _0912_ net220 VGND VGND VPWR VPWR _0917_ sky130_fd_sc_hd__a21oi_1
X_2615_ clknet_leaf_15_clk _0181_ _0023_ VGND VGND VPWR VPWR rx_fifo.fifo\[15\]\[0\]
+ sky130_fd_sc_hd__edfxtp_1
XFILLER_0_27_164 VGND VGND VPWR VPWR sky130_fd_sc_hd__decap_4
XFILLER_0_2_264 VGND VGND VPWR VPWR sky130_fd_sc_hd__fill_1
XFILLER_0_15_337 VGND VGND VPWR VPWR sky130_fd_sc_hd__decap_8
X_1428_ rx.baud_cnt\[2\] rx.baud_cnt\[0\] rx.baud_cnt\[1\] VGND VGND VPWR VPWR _0652_
+ sky130_fd_sc_hd__and3_1
XFILLER_0_48_3 VGND VGND VPWR VPWR sky130_fd_sc_hd__decap_3
X_2546_ clknet_leaf_27_clk _0234_ net89 VGND VGND VPWR VPWR rx_fifo.fifo\[11\]\[8\]
+ sky130_fd_sc_hd__edfxtp_1
X_2477_ _0903_ net54 VGND VGND VPWR VPWR _0468_ sky130_fd_sc_hd__nor2_1
X_1359_ divisor\[6\] _0589_ VGND VGND VPWR VPWR _0598_ sky130_fd_sc_hd__xnor2_1
XFILLER_0_73_281 VPWR VGND VPWR VGND sky130_ef_sc_hd__decap_12
XFILLER_0_65_237 VGND VGND VPWR VPWR sky130_fd_sc_hd__decap_4
Xwire128 _0829_ VGND VGND VPWR VPWR net128 sky130_fd_sc_hd__buf_1
Xwire139 _1066_ VGND VGND VPWR VPWR net139 sky130_fd_sc_hd__clkbuf_1
XFILLER_0_18_197 VGND VGND VPWR VPWR sky130_fd_sc_hd__decap_6
Xfanout250 net251 VGND VGND VPWR VPWR net250 sky130_fd_sc_hd__clkbuf_4
Xfanout261 net5 VGND VGND VPWR VPWR net261 sky130_fd_sc_hd__buf_2
XFILLER_0_56_248 VGND VGND VPWR VPWR sky130_fd_sc_hd__decap_4
XFILLER_0_64_292 VGND VGND VPWR VPWR sky130_fd_sc_hd__fill_2
XFILLER_0_52_421 VGND VGND VPWR VPWR sky130_fd_sc_hd__decap_6
X_2400_ rx.shift_reg\[4\] rx.shift_reg\[5\] rx.shift_reg\[2\] rx.shift_reg\[3\] VGND
+ VGND VPWR VPWR _1194_ sky130_fd_sc_hd__nor4_1
XFILLER_0_21_57 VGND VGND VPWR VPWR sky130_fd_sc_hd__fill_2
X_2262_ net11 divisor\[4\] net183 VGND VGND VPWR VPWR _0089_ sky130_fd_sc_hd__mux2_1
X_2331_ net77 _1158_ _1160_ _1157_ VGND VGND VPWR VPWR _0128_ sky130_fd_sc_hd__o31ai_1
XFILLER_0_62_42 VGND VGND VPWR VPWR sky130_fd_sc_hd__decap_4
X_2193_ net233 net126 net221 VGND VGND VPWR VPWR _1083_ sky130_fd_sc_hd__a21oi_1
X_1977_ net67 _0908_ VGND VGND VPWR VPWR _0496_ sky130_fd_sc_hd__nor2_1
XFILLER_0_7_301 VPWR VGND VPWR VGND sky130_ef_sc_hd__decap_12
X_2529_ clknet_leaf_17_clk _0195_ net86 VGND VGND VPWR VPWR rx_fifo.fifo\[14\]\[2\]
+ sky130_fd_sc_hd__edfxtp_1
Xhold25 regs.dlh\[2\] VGND VGND VPWR VPWR net286 sky130_fd_sc_hd__dlygate4sd3_1
Xhold69 regs.dlh\[6\] VGND VGND VPWR VPWR net330 sky130_fd_sc_hd__dlygate4sd3_1
Xhold58 _0132_ VGND VGND VPWR VPWR net319 sky130_fd_sc_hd__dlygate4sd3_1
Xhold14 tx.shift_reg\[3\] VGND VGND VPWR VPWR net275 sky130_fd_sc_hd__dlygate4sd3_1
Xhold47 tx.shift_reg\[0\] VGND VGND VPWR VPWR net308 sky130_fd_sc_hd__dlygate4sd3_1
Xhold36 regs.rx_data\[3\] VGND VGND VPWR VPWR net297 sky130_fd_sc_hd__dlygate4sd3_1
XFILLER_0_21_137 VPWR VGND VPWR VGND sky130_ef_sc_hd__decap_12
XFILLER_0_19_462 VGND VGND VPWR VPWR sky130_fd_sc_hd__fill_1
X_2880_ clknet_leaf_12_clk _0089_ net249 VGND VGND VPWR VPWR divisor\[4\] sky130_fd_sc_hd__dfrtp_4
X_1831_ net105 _0873_ VGND VGND VPWR VPWR _0349_ sky130_fd_sc_hd__nor2_1
XFILLER_0_37_281 VGND VGND VPWR VPWR sky130_fd_sc_hd__fill_1
XFILLER_0_32_23 VGND VGND VPWR VPWR sky130_fd_sc_hd__fill_2
XFILLER_0_29_237 VGND VGND VPWR VPWR sky130_fd_sc_hd__decap_4
X_1900_ net72 _0897_ VGND VGND VPWR VPWR _0427_ sky130_fd_sc_hd__nor2_1
X_1693_ net111 net157 VGND VGND VPWR VPWR _0220_ sky130_fd_sc_hd__nor2_1
X_1762_ net109 net151 VGND VGND VPWR VPWR _0285_ sky130_fd_sc_hd__nor2_1
XFILLER_0_52_295 VGND VGND VPWR VPWR sky130_fd_sc_hd__decap_8
XFILLER_0_40_446 VGND VGND VPWR VPWR sky130_fd_sc_hd__decap_3
XFILLER_0_40_435 VGND VGND VPWR VPWR sky130_fd_sc_hd__fill_2
Xmax_cap203 net204 VGND VGND VPWR VPWR net203 sky130_fd_sc_hd__buf_1
XFILLER_0_57_97 VGND VGND VPWR VPWR sky130_fd_sc_hd__fill_2
X_2245_ net15 _0713_ VGND VGND VPWR VPWR _1125_ sky130_fd_sc_hd__nand2_2
X_2314_ net343 _1143_ _1144_ _1146_ VGND VGND VPWR VPWR _0125_ sky130_fd_sc_hd__o2bb2ai_1
X_2176_ net301 _0991_ _0992_ tx.shift_reg\[1\] _1069_ VGND VGND VPWR VPWR _0065_ sky130_fd_sc_hd__a221o_1
XFILLER_0_20_192 VGND VGND VPWR VPWR sky130_fd_sc_hd__fill_1
XFILLER_0_75_387 VGND VGND VPWR VPWR sky130_fd_sc_hd__decap_4
XFILLER_0_43_273 VGND VGND VPWR VPWR sky130_fd_sc_hd__decap_6
XFILLER_0_7_120 VGND VGND VPWR VPWR sky130_fd_sc_hd__decap_8
XFILLER_0_7_164 VGND VGND VPWR VPWR sky130_fd_sc_hd__decap_4
Xoutput26 net26 VGND VGND VPWR VPWR rdata[2] sky130_fd_sc_hd__clkbuf_4
XPHY_154 VGND VGND VPWR VPWR sky130_fd_sc_hd__decap_3
XPHY_143 VGND VGND VPWR VPWR sky130_fd_sc_hd__decap_3
XFILLER_0_66_365 VPWR VGND VPWR VGND sky130_ef_sc_hd__decap_12
XPHY_132 VGND VGND VPWR VPWR sky130_fd_sc_hd__decap_3
XPHY_121 VGND VGND VPWR VPWR sky130_fd_sc_hd__decap_3
XPHY_110 VGND VGND VPWR VPWR sky130_fd_sc_hd__decap_3
XFILLER_0_19_281 VGND VGND VPWR VPWR sky130_fd_sc_hd__decap_3
XFILLER_0_22_402 VPWR VGND VPWR VGND sky130_ef_sc_hd__decap_12
XFILLER_0_27_12 VGND VGND VPWR VPWR sky130_fd_sc_hd__fill_1
X_2030_ rx.state\[1\] rx.state\[0\] net232 VGND VGND VPWR VPWR _0948_ sky130_fd_sc_hd__nand3b_1
XFILLER_0_57_332 VGND VGND VPWR VPWR sky130_fd_sc_hd__decap_4
XFILLER_0_43_77 VGND VGND VPWR VPWR sky130_fd_sc_hd__decap_8
XPHY_1 VGND VGND VPWR VPWR sky130_fd_sc_hd__decap_3
X_2932_ clknet_leaf_31_clk _0049_ net258 VGND VGND VPWR VPWR rx.shift_reg\[1\] sky130_fd_sc_hd__dfrtp_2
XFILLER_0_72_302 VGND VGND VPWR VPWR sky130_fd_sc_hd__decap_6
XFILLER_0_57_398 VPWR VGND VPWR VGND sky130_ef_sc_hd__decap_12
X_1814_ net118 net146 VGND VGND VPWR VPWR _0344_ sky130_fd_sc_hd__nor2_1
X_1745_ rx_fifo.tail\[1\] net233 net389 VGND VGND VPWR VPWR _0865_ sky130_fd_sc_hd__nand3_2
X_2863_ clknet_leaf_5_clk _0103_ net247 VGND VGND VPWR VPWR parity_type sky130_fd_sc_hd__dfrtp_4
XFILLER_0_25_273 VGND VGND VPWR VPWR sky130_fd_sc_hd__decap_6
XFILLER_0_25_251 VGND VGND VPWR VPWR sky130_fd_sc_hd__decap_6
Xclkbuf_leaf_42_clk clknet_2_0__leaf_clk VGND VGND VPWR VPWR clknet_leaf_42_clk sky130_fd_sc_hd__clkbuf_16
X_2794_ clknet_leaf_40_clk _0452_ net41 VGND VGND VPWR VPWR tx_fifo.fifo\[6\]\[7\]
+ sky130_fd_sc_hd__edfxtp_1
XFILLER_0_68_85 VGND VGND VPWR VPWR sky130_fd_sc_hd__fill_2
XTAP_652 VGND VPWR sky130_fd_sc_hd__tapvpwrvgnd_1
XTAP_641 VGND VPWR sky130_fd_sc_hd__tapvpwrvgnd_1
XTAP_630 VGND VPWR sky130_fd_sc_hd__tapvpwrvgnd_1
X_1676_ rx_fifo.tail\[2\] rx_fifo.tail\[3\] _0855_ VGND VGND VPWR VPWR _0856_ sky130_fd_sc_hd__nand3_2
XTAP_696 VGND VPWR sky130_fd_sc_hd__tapvpwrvgnd_1
XTAP_685 VGND VPWR sky130_fd_sc_hd__tapvpwrvgnd_1
XTAP_674 VGND VPWR sky130_fd_sc_hd__tapvpwrvgnd_1
XTAP_663 VGND VPWR sky130_fd_sc_hd__tapvpwrvgnd_1
X_2159_ _1049_ _1051_ _1052_ _1053_ VGND VGND VPWR VPWR _1054_ sky130_fd_sc_hd__nand4_1
X_2228_ tx.bit_cnt\[2\] tx.bit_cnt\[1\] VGND VGND VPWR VPWR _1110_ sky130_fd_sc_hd__nor2_1
Xclkbuf_leaf_33_clk clknet_2_1__leaf_clk VGND VGND VPWR VPWR clknet_leaf_33_clk sky130_fd_sc_hd__clkbuf_16
XFILLER_0_31_243 VGND VGND VPWR VPWR sky130_fd_sc_hd__fill_1
XFILLER_0_16_251 VGND VGND VPWR VPWR sky130_fd_sc_hd__fill_1
Xclkbuf_leaf_24_clk clknet_2_3__leaf_clk VGND VGND VPWR VPWR clknet_leaf_24_clk sky130_fd_sc_hd__clkbuf_16
XFILLER_0_39_376 VGND VGND VPWR VPWR sky130_fd_sc_hd__fill_2
X_1392_ tx.baud_cnt\[4\] tx.baud_cnt\[3\] _0630_ VGND VGND VPWR VPWR _0631_ sky130_fd_sc_hd__and3_1
X_1461_ divisor\[4\] divisor\[5\] divisor\[6\] VGND VGND VPWR VPWR _0682_ sky130_fd_sc_hd__o21a_1
X_1530_ _0726_ _0732_ _0736_ _0738_ net4 VGND VGND VPWR VPWR net30 sky130_fd_sc_hd__o41a_1
XFILLER_0_77_405 VPWR VGND VPWR VGND sky130_ef_sc_hd__decap_12
XFILLER_0_54_32 VPWR VGND VPWR VGND sky130_ef_sc_hd__decap_12
XFILLER_0_38_77 VGND VGND VPWR VPWR sky130_fd_sc_hd__decap_6
X_2013_ _0511_ _0922_ VGND VGND VPWR VPWR _0933_ sky130_fd_sc_hd__nor2b_1
XFILLER_0_77_449 VGND VGND VPWR VPWR sky130_fd_sc_hd__decap_8
Xclkbuf_leaf_15_clk clknet_2_2__leaf_clk VGND VGND VPWR VPWR clknet_leaf_15_clk sky130_fd_sc_hd__clkbuf_16
XFILLER_0_57_184 VGND VGND VPWR VPWR sky130_fd_sc_hd__fill_1
XFILLER_0_57_173 VGND VGND VPWR VPWR sky130_fd_sc_hd__fill_1
XFILLER_0_45_335 VGND VGND VPWR VPWR sky130_fd_sc_hd__fill_1
X_2915_ clknet_leaf_35_clk net264 net254 VGND VGND VPWR VPWR tx.shift_reg\[6\] sky130_fd_sc_hd__dfrtp_1
Xhold111 tx.baud_cnt\[7\] VGND VGND VPWR VPWR net372 sky130_fd_sc_hd__dlygate4sd3_1
Xhold100 tx.baud_cnt\[4\] VGND VGND VPWR VPWR net361 sky130_fd_sc_hd__dlygate4sd3_1
XFILLER_0_70_97 VGND VGND VPWR VPWR sky130_fd_sc_hd__fill_2
XFILLER_0_60_305 VGND VGND VPWR VPWR sky130_fd_sc_hd__decap_3
X_2846_ clknet_leaf_12_clk _0118_ net249 VGND VGND VPWR VPWR net22 sky130_fd_sc_hd__dfrtp_1
X_1728_ net110 net154 VGND VGND VPWR VPWR _0252_ sky130_fd_sc_hd__nor2_1
X_2777_ clknet_leaf_4_clk _0379_ _0007_ VGND VGND VPWR VPWR tx_fifo.fifo\[15\]\[6\]
+ sky130_fd_sc_hd__edfxtp_1
XTAP_493 VGND VPWR sky130_fd_sc_hd__tapvpwrvgnd_1
XTAP_482 VGND VPWR sky130_fd_sc_hd__tapvpwrvgnd_1
XTAP_471 VGND VPWR sky130_fd_sc_hd__tapvpwrvgnd_1
XTAP_460 VGND VPWR sky130_fd_sc_hd__tapvpwrvgnd_1
X_1659_ regs.rx_data\[1\] net125 VGND VGND VPWR VPWR _0851_ sky130_fd_sc_hd__nand2_1
XFILLER_0_0_181 VGND VGND VPWR VPWR sky130_fd_sc_hd__decap_4
XFILLER_0_59_449 VPWR VGND VPWR VGND sky130_ef_sc_hd__decap_12
XFILLER_0_27_335 VGND VGND VPWR VPWR sky130_fd_sc_hd__fill_1
XFILLER_0_27_302 VGND VGND VPWR VPWR sky130_fd_sc_hd__decap_4
XFILLER_0_6_207 VGND VGND VPWR VPWR sky130_fd_sc_hd__fill_1
X_2562_ clknet_leaf_19_clk _0338_ net85 VGND VGND VPWR VPWR rx_fifo.fifo\[1\]\[2\]
+ sky130_fd_sc_hd__edfxtp_1
X_2631_ clknet_leaf_18_clk _0297_ net99 VGND VGND VPWR VPWR rx_fifo.fifo\[5\]\[5\]
+ sky130_fd_sc_hd__edfxtp_1
X_2700_ clknet_leaf_28_clk _0245_ net92 VGND VGND VPWR VPWR rx_fifo.fifo\[10\]\[8\]
+ sky130_fd_sc_hd__edfxtp_1
XFILLER_0_2_457 VGND VGND VPWR VPWR sky130_fd_sc_hd__decap_6
XFILLER_0_2_413 VGND VGND VPWR VPWR sky130_fd_sc_hd__decap_6
X_1444_ divisor\[14\] _0578_ VGND VGND VPWR VPWR _0665_ sky130_fd_sc_hd__xor2_2
X_1513_ rx_fifo.fifo\[7\]\[6\] net172 net168 rx_fifo.fifo\[1\]\[6\] VGND VGND VPWR
+ VPWR _0722_ sky130_fd_sc_hd__a22oi_1
Xclkbuf_leaf_4_clk clknet_2_0__leaf_clk VGND VGND VPWR VPWR clknet_leaf_4_clk sky130_fd_sc_hd__clkbuf_16
X_2493_ _0905_ net55 VGND VGND VPWR VPWR _0476_ sky130_fd_sc_hd__nor2_1
X_1375_ tx.state\[0\] tx.state\[1\] VGND VGND VPWR VPWR _0614_ sky130_fd_sc_hd__nor2_1
XFILLER_0_65_86 VGND VGND VPWR VPWR sky130_fd_sc_hd__decap_4
XFILLER_0_33_305 VPWR VGND VPWR VGND sky130_ef_sc_hd__decap_12
XFILLER_0_60_157 VGND VGND VPWR VPWR sky130_fd_sc_hd__fill_1
XFILLER_0_41_382 VGND VGND VPWR VPWR sky130_fd_sc_hd__fill_1
XFILLER_0_5_284 VGND VGND VPWR VPWR sky130_fd_sc_hd__fill_1
X_2829_ clknet_leaf_39_clk _0415_ net57 VGND VGND VPWR VPWR tx_fifo.fifo\[10\]\[2\]
+ sky130_fd_sc_hd__edfxtp_1
XTAP_290 VGND VPWR sky130_fd_sc_hd__tapvpwrvgnd_1
XFILLER_0_68_246 VGND VGND VPWR VPWR sky130_fd_sc_hd__decap_6
XFILLER_0_56_419 VGND VGND VPWR VPWR sky130_fd_sc_hd__fill_1
Xfanout83 _0027_ VGND VGND VPWR VPWR net83 sky130_fd_sc_hd__buf_4
XFILLER_0_36_121 VGND VGND VPWR VPWR sky130_fd_sc_hd__decap_8
Xfanout61 _0887_ VGND VGND VPWR VPWR net61 sky130_fd_sc_hd__buf_2
Xfanout72 _0881_ VGND VGND VPWR VPWR net72 sky130_fd_sc_hd__clkbuf_4
XFILLER_0_10_15 VPWR VGND VPWR VGND sky130_ef_sc_hd__decap_12
XFILLER_0_32_371 VGND VGND VPWR VPWR sky130_fd_sc_hd__decap_4
XFILLER_0_59_257 VPWR VGND VPWR VGND sky130_ef_sc_hd__decap_12
XFILLER_0_51_11 VGND VGND VPWR VPWR sky130_fd_sc_hd__fill_2
X_1993_ net220 _0914_ _0916_ VGND VGND VPWR VPWR _0036_ sky130_fd_sc_hd__nor3_1
XFILLER_0_15_305 VGND VGND VPWR VPWR sky130_fd_sc_hd__fill_1
X_2545_ clknet_leaf_17_clk _0233_ net89 VGND VGND VPWR VPWR rx_fifo.fifo\[11\]\[7\]
+ sky130_fd_sc_hd__edfxtp_1
X_2614_ clknet_leaf_16_clk _0303_ net80 VGND VGND VPWR VPWR rx_fifo.fifo\[4\]\[10\]
+ sky130_fd_sc_hd__edfxtp_1
XFILLER_0_23_393 VGND VGND VPWR VPWR sky130_fd_sc_hd__decap_4
XFILLER_0_76_85 VPWR VGND VPWR VGND sky130_ef_sc_hd__decap_12
XFILLER_0_76_41 VPWR VGND VPWR VGND sky130_ef_sc_hd__decap_12
X_1427_ net277 net53 VGND VGND VPWR VPWR _0357_ sky130_fd_sc_hd__nor2_1
X_1358_ tx.baud_cnt\[10\] _0596_ VGND VGND VPWR VPWR _0597_ sky130_fd_sc_hd__xnor2_1
X_2476_ _0949_ _0974_ _1226_ net324 VGND VGND VPWR VPWR _0143_ sky130_fd_sc_hd__o31a_1
X_1289_ rx_fifo.head\[3\] net234 _0520_ VGND VGND VPWR VPWR _0531_ sky130_fd_sc_hd__nor3_2
XFILLER_0_61_455 VGND VGND VPWR VPWR sky130_fd_sc_hd__decap_8
Xwire129 _0803_ VGND VGND VPWR VPWR net129 sky130_fd_sc_hd__buf_1
XFILLER_0_33_157 VGND VGND VPWR VPWR sky130_fd_sc_hd__fill_1
XFILLER_0_33_113 VPWR VGND VPWR VGND sky130_ef_sc_hd__decap_12
XFILLER_0_18_121 VPWR VGND VPWR VGND sky130_ef_sc_hd__decap_12
Xfanout240 net252 VGND VGND VPWR VPWR net240 sky130_fd_sc_hd__buf_4
Xfanout251 net252 VGND VGND VPWR VPWR net251 sky130_fd_sc_hd__clkbuf_2
XFILLER_0_21_36 VPWR VGND VPWR VGND sky130_ef_sc_hd__decap_12
XFILLER_0_24_135 VGND VGND VPWR VPWR sky130_fd_sc_hd__decap_4
X_2261_ net12 divisor\[5\] net182 VGND VGND VPWR VPWR _0088_ sky130_fd_sc_hd__mux2_1
X_2192_ net221 _0840_ _1082_ VGND VGND VPWR VPWR _0068_ sky130_fd_sc_hd__nor3_1
X_2330_ rx.sample_cnt\[1\] _0953_ _1159_ VGND VGND VPWR VPWR _1160_ sky130_fd_sc_hd__a21oi_1
XFILLER_0_20_363 VGND VGND VPWR VPWR sky130_fd_sc_hd__fill_1
XFILLER_0_62_21 VGND VGND VPWR VPWR sky130_fd_sc_hd__fill_1
XFILLER_0_1_57 VGND VGND VPWR VPWR sky130_fd_sc_hd__decap_8
XFILLER_0_1_79 VGND VGND VPWR VPWR sky130_fd_sc_hd__fill_2
XFILLER_0_43_433 VGND VGND VPWR VPWR sky130_fd_sc_hd__decap_3
X_1976_ net69 _0908_ VGND VGND VPWR VPWR _0497_ sky130_fd_sc_hd__nor2_1
XFILLER_0_7_313 VPWR VGND VPWR VGND sky130_ef_sc_hd__decap_12
XFILLER_0_15_113 VGND VGND VPWR VPWR sky130_fd_sc_hd__fill_1
XFILLER_0_60_3 VGND VGND VPWR VPWR sky130_fd_sc_hd__decap_8
X_2528_ clknet_leaf_23_clk _0194_ net86 VGND VGND VPWR VPWR rx_fifo.fifo\[14\]\[1\]
+ sky130_fd_sc_hd__edfxtp_1
XFILLER_0_30_138 VGND VGND VPWR VPWR sky130_fd_sc_hd__fill_2
XFILLER_0_30_116 VPWR VGND VPWR VGND sky130_ef_sc_hd__decap_12
Xhold26 regs.dlh\[1\] VGND VGND VPWR VPWR net287 sky130_fd_sc_hd__dlygate4sd3_1
X_2459_ net36 _1220_ net4 VGND VGND VPWR VPWR net31 sky130_fd_sc_hd__a21boi_2
Xhold59 regs.tx_data\[7\] VGND VGND VPWR VPWR net320 sky130_fd_sc_hd__dlygate4sd3_1
Xhold15 _0064_ VGND VGND VPWR VPWR net276 sky130_fd_sc_hd__dlygate4sd3_1
Xhold48 _0066_ VGND VGND VPWR VPWR net309 sky130_fd_sc_hd__dlygate4sd3_1
Xhold37 _0056_ VGND VGND VPWR VPWR net298 sky130_fd_sc_hd__dlygate4sd3_1
XFILLER_0_53_208 VPWR VGND VPWR VGND sky130_ef_sc_hd__decap_12
XFILLER_0_21_149 VGND VGND VPWR VPWR sky130_fd_sc_hd__fill_1
XFILLER_0_69_330 VGND VGND VPWR VPWR sky130_fd_sc_hd__decap_6
X_1761_ net111 net151 VGND VGND VPWR VPWR _0286_ sky130_fd_sc_hd__nor2_1
X_1830_ net107 net145 VGND VGND VPWR VPWR _0350_ sky130_fd_sc_hd__nor2_1
XFILLER_0_37_260 VGND VGND VPWR VPWR sky130_fd_sc_hd__decap_4
XFILLER_0_25_433 VGND VGND VPWR VPWR sky130_fd_sc_hd__decap_8
XFILLER_0_25_411 VGND VGND VPWR VPWR sky130_fd_sc_hd__decap_3
XFILLER_0_4_305 VGND VGND VPWR VPWR sky130_fd_sc_hd__decap_3
X_1692_ net113 net157 VGND VGND VPWR VPWR _0221_ sky130_fd_sc_hd__nor2_1
Xmax_cap204 net205 VGND VGND VPWR VPWR net204 sky130_fd_sc_hd__clkbuf_2
X_2313_ tx.bit_cnt\[1\] tx.bit_cnt\[0\] VGND VGND VPWR VPWR _1146_ sky130_fd_sc_hd__xnor2_1
X_2175_ net75 _1068_ VGND VGND VPWR VPWR _1069_ sky130_fd_sc_hd__nor2_1
X_2244_ net75 _1120_ _1124_ VGND VGND VPWR VPWR _0078_ sky130_fd_sc_hd__nand3_1
XFILLER_0_22_90 VGND VGND VPWR VPWR sky130_fd_sc_hd__fill_2
X_1959_ net70 _0906_ VGND VGND VPWR VPWR _0482_ sky130_fd_sc_hd__nor2_1
XFILLER_0_7_154 VGND VGND VPWR VPWR sky130_fd_sc_hd__decap_6
XFILLER_0_3_393 VPWR VGND VPWR VGND sky130_ef_sc_hd__decap_12
Xoutput16 net16 VGND VGND VPWR VPWR break_int sky130_fd_sc_hd__clkbuf_4
Xoutput27 net27 VGND VGND VPWR VPWR rdata[3] sky130_fd_sc_hd__clkbuf_4
XPHY_100 VGND VGND VPWR VPWR sky130_fd_sc_hd__decap_3
XPHY_155 VGND VGND VPWR VPWR sky130_fd_sc_hd__decap_3
XPHY_144 VGND VGND VPWR VPWR sky130_fd_sc_hd__decap_3
XPHY_133 VGND VGND VPWR VPWR sky130_fd_sc_hd__decap_3
XFILLER_0_66_377 VGND VGND VPWR VPWR sky130_fd_sc_hd__decap_3
XFILLER_0_66_333 VGND VGND VPWR VPWR sky130_fd_sc_hd__decap_8
XPHY_122 VGND VGND VPWR VPWR sky130_fd_sc_hd__decap_3
XPHY_111 VGND VGND VPWR VPWR sky130_fd_sc_hd__decap_3
XFILLER_0_22_414 VGND VGND VPWR VPWR sky130_fd_sc_hd__decap_6
Xclkbuf_0_clk clk VGND VGND VPWR VPWR clknet_0_clk sky130_fd_sc_hd__clkbuf_16
XPHY_2 VGND VGND VPWR VPWR sky130_fd_sc_hd__decap_3
X_2931_ clknet_leaf_31_clk _0050_ net258 VGND VGND VPWR VPWR rx.shift_reg\[0\] sky130_fd_sc_hd__dfrtp_1
X_1813_ net119 _0872_ VGND VGND VPWR VPWR _0345_ sky130_fd_sc_hd__nor2_1
X_1744_ rx_fifo.tail\[2\] rx_fifo.tail\[3\] VGND VGND VPWR VPWR _0864_ sky130_fd_sc_hd__lpflow_isobufsrc_1
X_2862_ clknet_leaf_5_clk _0104_ net247 VGND VGND VPWR VPWR parity_en sky130_fd_sc_hd__dfrtp_4
X_2793_ clknet_leaf_42_clk _0451_ _0005_ VGND VGND VPWR VPWR tx_fifo.fifo\[6\]\[6\]
+ sky130_fd_sc_hd__edfxtp_1
XFILLER_0_13_436 VGND VGND VPWR VPWR sky130_fd_sc_hd__decap_4
XFILLER_0_13_458 VGND VGND VPWR VPWR sky130_fd_sc_hd__fill_1
XTAP_686 VGND VPWR sky130_fd_sc_hd__tapvpwrvgnd_1
XTAP_675 VGND VPWR sky130_fd_sc_hd__tapvpwrvgnd_1
XTAP_664 VGND VPWR sky130_fd_sc_hd__tapvpwrvgnd_1
XTAP_653 VGND VPWR sky130_fd_sc_hd__tapvpwrvgnd_1
XTAP_642 VGND VPWR sky130_fd_sc_hd__tapvpwrvgnd_1
XTAP_631 VGND VPWR sky130_fd_sc_hd__tapvpwrvgnd_1
XTAP_620 VGND VPWR sky130_fd_sc_hd__tapvpwrvgnd_1
X_1675_ net233 rx_fifo.tail\[1\] VGND VGND VPWR VPWR _0855_ sky130_fd_sc_hd__lpflow_isobufsrc_1
XFILLER_0_0_363 VGND VGND VPWR VPWR sky130_fd_sc_hd__fill_1
XTAP_697 VGND VPWR sky130_fd_sc_hd__tapvpwrvgnd_1
XFILLER_0_23_3 VGND VGND VPWR VPWR sky130_fd_sc_hd__decap_6
X_2089_ net212 _0912_ VGND VGND VPWR VPWR _0988_ sky130_fd_sc_hd__nand2_1
X_2158_ tx_fifo.fifo\[4\]\[2\] _1006_ net186 tx_fifo.fifo\[6\]\[2\] tx_fifo.fifo\[12\]\[2\]
+ net387 VGND VGND VPWR VPWR _1053_ sky130_fd_sc_hd__a222oi_1
X_2227_ tx.state\[2\] _0614_ VGND VGND VPWR VPWR _1109_ sky130_fd_sc_hd__and2_0
XFILLER_0_75_130 VPWR VGND VPWR VGND sky130_ef_sc_hd__decap_12
XFILLER_0_71_391 VGND VGND VPWR VPWR sky130_fd_sc_hd__fill_1
XFILLER_0_58_119 VGND VGND VPWR VPWR sky130_fd_sc_hd__fill_1
XFILLER_0_13_15 VGND VGND VPWR VPWR sky130_fd_sc_hd__decap_3
XFILLER_0_39_399 VPWR VGND VPWR VGND sky130_ef_sc_hd__decap_12
XFILLER_0_22_233 VGND VGND VPWR VPWR sky130_fd_sc_hd__decap_4
XFILLER_0_1_105 VGND VGND VPWR VPWR sky130_fd_sc_hd__decap_6
X_1391_ tx.baud_cnt\[2\] tx.baud_cnt\[1\] tx.baud_cnt\[0\] VGND VGND VPWR VPWR _0630_
+ sky130_fd_sc_hd__and3_1
X_1460_ rx.baud_cnt\[3\] divisor\[7\] net213 VGND VGND VPWR VPWR _0681_ sky130_fd_sc_hd__xnor3_1
XFILLER_0_77_417 VGND VGND VPWR VPWR sky130_fd_sc_hd__decap_3
XFILLER_0_54_44 VGND VGND VPWR VPWR sky130_fd_sc_hd__decap_8
X_2012_ tx_fifo.count\[1\] _0920_ VGND VGND VPWR VPWR _0932_ sky130_fd_sc_hd__nand2_1
X_2845_ clknet_leaf_15_clk _0119_ net250 VGND VGND VPWR VPWR net21 sky130_fd_sc_hd__dfrtp_2
X_2914_ clknet_leaf_35_clk net295 net254 VGND VGND VPWR VPWR tx.shift_reg\[5\] sky130_fd_sc_hd__dfrtp_1
XFILLER_0_9_205 VGND VGND VPWR VPWR sky130_fd_sc_hd__fill_2
Xhold112 tx.baud_cnt\[12\] VGND VGND VPWR VPWR net373 sky130_fd_sc_hd__dlygate4sd3_1
Xhold101 net18 VGND VGND VPWR VPWR net362 sky130_fd_sc_hd__dlygate4sd3_1
X_1658_ net210 net106 VGND VGND VPWR VPWR _0184_ sky130_fd_sc_hd__nor2_1
X_1727_ net112 net154 VGND VGND VPWR VPWR _0253_ sky130_fd_sc_hd__nor2_1
X_2776_ clknet_leaf_41_clk _0378_ net43 VGND VGND VPWR VPWR tx_fifo.fifo\[15\]\[5\]
+ sky130_fd_sc_hd__edfxtp_1
X_1589_ _0784_ _0793_ _0714_ VGND VGND VPWR VPWR _0794_ sky130_fd_sc_hd__a21oi_1
XTAP_494 VGND VPWR sky130_fd_sc_hd__tapvpwrvgnd_1
XTAP_483 VGND VPWR sky130_fd_sc_hd__tapvpwrvgnd_1
XTAP_472 VGND VPWR sky130_fd_sc_hd__tapvpwrvgnd_1
XTAP_461 VGND VPWR sky130_fd_sc_hd__tapvpwrvgnd_1
XTAP_450 VGND VPWR sky130_fd_sc_hd__tapvpwrvgnd_1
XFILLER_0_48_141 VGND VGND VPWR VPWR sky130_fd_sc_hd__fill_1
XFILLER_0_67_461 VGND VGND VPWR VPWR sky130_fd_sc_hd__fill_2
XFILLER_0_39_196 VGND VGND VPWR VPWR sky130_fd_sc_hd__fill_1
XFILLER_0_39_130 VGND VGND VPWR VPWR sky130_fd_sc_hd__fill_2
XFILLER_0_27_314 VPWR VGND VPWR VGND sky130_ef_sc_hd__decap_12
X_2561_ clknet_leaf_21_clk _0337_ net85 VGND VGND VPWR VPWR rx_fifo.fifo\[1\]\[1\]
+ sky130_fd_sc_hd__edfxtp_1
X_2630_ clknet_leaf_20_clk _0296_ net99 VGND VGND VPWR VPWR rx_fifo.fifo\[5\]\[4\]
+ sky130_fd_sc_hd__edfxtp_1
XFILLER_0_50_361 VGND VGND VPWR VPWR sky130_fd_sc_hd__decap_3
XFILLER_0_49_55 VGND VGND VPWR VPWR sky130_fd_sc_hd__fill_1
XFILLER_0_40_57 VGND VGND VPWR VPWR sky130_fd_sc_hd__fill_1
X_1512_ rx_fifo.fifo\[0\]\[6\] net215 net161 rx_fifo.fifo\[9\]\[6\] VGND VGND VPWR
+ VPWR _0721_ sky130_fd_sc_hd__a22oi_1
XFILLER_0_35_391 VGND VGND VPWR VPWR sky130_fd_sc_hd__fill_1
X_2492_ _1236_ _1238_ VGND VGND VPWR VPWR _0145_ sky130_fd_sc_hd__nand2_1
X_1374_ divisor\[8\] _0572_ VGND VGND VPWR VPWR _0613_ sky130_fd_sc_hd__xor2_1
X_1443_ divisor\[14\] _0578_ _0503_ divisor\[15\] VGND VGND VPWR VPWR _0664_ sky130_fd_sc_hd__o211ai_2
XFILLER_0_77_225 VPWR VGND VPWR VGND sky130_ef_sc_hd__decap_12
XFILLER_0_45_133 VPWR VGND VPWR VGND sky130_ef_sc_hd__decap_12
XFILLER_0_33_317 VPWR VGND VPWR VGND sky130_ef_sc_hd__decap_12
X_2828_ clknet_leaf_41_clk _0414_ net380 VGND VGND VPWR VPWR tx_fifo.fifo\[10\]\[1\]
+ sky130_fd_sc_hd__edfxtp_1
X_2759_ clknet_leaf_42_clk _0473_ _0009_ VGND VGND VPWR VPWR tx_fifo.fifo\[3\]\[4\]
+ sky130_fd_sc_hd__edfxtp_1
XTAP_280 VGND VPWR sky130_fd_sc_hd__tapvpwrvgnd_1
XTAP_291 VGND VPWR sky130_fd_sc_hd__tapvpwrvgnd_1
XFILLER_0_68_269 VGND VGND VPWR VPWR sky130_fd_sc_hd__fill_1
Xfanout73 _0881_ VGND VGND VPWR VPWR net73 sky130_fd_sc_hd__clkbuf_2
Xfanout62 _0886_ VGND VGND VPWR VPWR net62 sky130_fd_sc_hd__clkbuf_4
XFILLER_0_51_169 VGND VGND VPWR VPWR sky130_fd_sc_hd__decap_4
Xfanout95 _0018_ VGND VGND VPWR VPWR net95 sky130_fd_sc_hd__buf_4
XFILLER_0_24_306 VGND VGND VPWR VPWR sky130_fd_sc_hd__fill_2
XFILLER_0_10_27 VGND VGND VPWR VPWR sky130_fd_sc_hd__fill_1
XFILLER_0_59_269 VGND VGND VPWR VPWR sky130_fd_sc_hd__decap_8
XFILLER_0_59_225 VGND VGND VPWR VPWR sky130_fd_sc_hd__decap_4
XFILLER_0_35_57 VGND VGND VPWR VPWR sky130_fd_sc_hd__decap_6
XFILLER_0_35_13 VGND VGND VPWR VPWR sky130_fd_sc_hd__decap_8
XFILLER_0_70_445 VPWR VGND VPWR VGND sky130_ef_sc_hd__decap_12
XFILLER_0_70_401 VGND VGND VPWR VPWR sky130_fd_sc_hd__decap_4
X_1992_ net231 _0912_ net229 VGND VGND VPWR VPWR _0916_ sky130_fd_sc_hd__a21oi_1
X_2613_ clknet_leaf_14_clk _0312_ net80 VGND VGND VPWR VPWR rx_fifo.fifo\[4\]\[9\]
+ sky130_fd_sc_hd__edfxtp_1
X_2544_ clknet_leaf_29_clk _0232_ net89 VGND VGND VPWR VPWR rx_fifo.fifo\[11\]\[6\]
+ sky130_fd_sc_hd__edfxtp_1
XFILLER_0_2_288 VGND VGND VPWR VPWR sky130_fd_sc_hd__fill_2
X_2475_ _0947_ _0972_ VGND VGND VPWR VPWR _1226_ sky130_fd_sc_hd__nor2_1
XFILLER_0_76_97 VGND VGND VPWR VPWR sky130_fd_sc_hd__decap_3
XFILLER_0_76_53 VGND VGND VPWR VPWR sky130_fd_sc_hd__decap_8
X_1426_ net53 _0651_ VGND VGND VPWR VPWR _0364_ sky130_fd_sc_hd__nor2_1
X_1357_ net214 net160 _0595_ VGND VGND VPWR VPWR _0596_ sky130_fd_sc_hd__o21ai_1
X_1288_ _0523_ _0528_ VGND VGND VPWR VPWR _0530_ sky130_fd_sc_hd__nor2_1
XFILLER_0_33_169 VGND VGND VPWR VPWR sky130_fd_sc_hd__decap_8
XFILLER_0_33_125 VPWR VGND VPWR VGND sky130_ef_sc_hd__decap_12
Xfanout252 net5 VGND VGND VPWR VPWR net252 sky130_fd_sc_hd__buf_2
Xfanout241 net246 VGND VGND VPWR VPWR net241 sky130_fd_sc_hd__clkbuf_4
Xfanout230 tx_fifo.head\[0\] VGND VGND VPWR VPWR net230 sky130_fd_sc_hd__clkbuf_4
XFILLER_0_21_48 VGND VGND VPWR VPWR sky130_fd_sc_hd__fill_1
XFILLER_0_32_180 VPWR VGND VPWR VGND sky130_ef_sc_hd__decap_12
XFILLER_0_12_309 VGND VGND VPWR VPWR sky130_fd_sc_hd__decap_8
X_2260_ net13 divisor\[6\] net182 VGND VGND VPWR VPWR _0087_ sky130_fd_sc_hd__mux2_1
X_2191_ net233 net126 rx_fifo.tail\[1\] VGND VGND VPWR VPWR _1082_ sky130_fd_sc_hd__a21oi_1
XFILLER_0_70_253 VPWR VGND VPWR VGND sky130_ef_sc_hd__decap_12
XFILLER_0_43_412 VGND VGND VPWR VPWR sky130_fd_sc_hd__fill_1
XFILLER_0_30_128 VGND VGND VPWR VPWR sky130_fd_sc_hd__fill_1
X_1975_ net71 _0908_ VGND VGND VPWR VPWR _0498_ sky130_fd_sc_hd__nor2_1
XFILLER_0_7_325 VGND VGND VPWR VPWR sky130_fd_sc_hd__decap_8
XFILLER_0_15_169 VGND VGND VPWR VPWR sky130_fd_sc_hd__decap_6
X_1409_ tx.baud_cnt\[9\] _0634_ VGND VGND VPWR VPWR _0643_ sky130_fd_sc_hd__xor2_1
Xhold16 tx.baud_cnt\[0\] VGND VGND VPWR VPWR net277 sky130_fd_sc_hd__dlygate4sd3_1
X_2527_ clknet_leaf_19_clk _0192_ net86 VGND VGND VPWR VPWR rx_fifo.fifo\[14\]\[0\]
+ sky130_fd_sc_hd__edfxtp_1
XFILLER_0_53_3 VPWR VGND VPWR VGND sky130_ef_sc_hd__decap_12
Xhold38 regs.mcr_reg\[6\] VGND VGND VPWR VPWR net299 sky130_fd_sc_hd__dlygate4sd3_1
X_2458_ net235 regs.dlh\[7\] _0728_ _1218_ _1219_ VGND VGND VPWR VPWR _1220_ sky130_fd_sc_hd__a311oi_2
XFILLER_0_23_180 VPWR VGND VPWR VGND sky130_ef_sc_hd__decap_12
Xhold27 regs.rx_data\[2\] VGND VGND VPWR VPWR net288 sky130_fd_sc_hd__dlygate4sd3_1
X_2389_ parity_type _1186_ VGND VGND VPWR VPWR _1187_ sky130_fd_sc_hd__xnor2_1
Xhold49 regs.rx_data\[0\] VGND VGND VPWR VPWR net310 sky130_fd_sc_hd__dlygate4sd3_1
XFILLER_0_16_15 VGND VGND VPWR VPWR sky130_fd_sc_hd__decap_4
XFILLER_0_69_386 VGND VGND VPWR VPWR sky130_fd_sc_hd__decap_6
X_1760_ net114 net151 VGND VGND VPWR VPWR _0287_ sky130_fd_sc_hd__nor2_1
X_1691_ net116 net157 VGND VGND VPWR VPWR _0222_ sky130_fd_sc_hd__nor2_1
XFILLER_0_52_253 VGND VGND VPWR VPWR sky130_fd_sc_hd__decap_6
XFILLER_0_37_294 VPWR VGND VPWR VGND sky130_ef_sc_hd__decap_12
XFILLER_0_25_423 VGND VGND VPWR VPWR sky130_fd_sc_hd__fill_2
Xmax_cap205 _0894_ VGND VGND VPWR VPWR net205 sky130_fd_sc_hd__clkbuf_2
XFILLER_0_4_339 VGND VGND VPWR VPWR sky130_fd_sc_hd__decap_8
XFILLER_0_4_317 VGND VGND VPWR VPWR sky130_fd_sc_hd__fill_2
Xmax_cap238 _0730_ VGND VGND VPWR VPWR net238 sky130_fd_sc_hd__clkbuf_2
X_2312_ tx.bit_cnt\[1\] tx.bit_cnt\[0\] VGND VGND VPWR VPWR _1145_ sky130_fd_sc_hd__nand2_1
X_2174_ tx_fifo.fifo\[3\]\[1\] net194 net187 tx_fifo.fifo\[6\]\[1\] _1067_ VGND VGND
+ VPWR VPWR _1068_ sky130_fd_sc_hd__a221oi_2
X_2243_ _1121_ _1123_ _1124_ VGND VGND VPWR VPWR _0077_ sky130_fd_sc_hd__or3b_1
XFILLER_0_75_334 VGND VGND VPWR VPWR sky130_fd_sc_hd__fill_2
XFILLER_0_28_283 VGND VGND VPWR VPWR sky130_fd_sc_hd__fill_1
Xoutput28 net28 VGND VGND VPWR VPWR rdata[4] sky130_fd_sc_hd__clkbuf_4
XFILLER_0_31_404 VGND VGND VPWR VPWR sky130_fd_sc_hd__fill_2
X_1958_ net72 _0906_ VGND VGND VPWR VPWR _0483_ sky130_fd_sc_hd__nor2_1
Xoutput17 net17 VGND VGND VPWR VPWR dr sky130_fd_sc_hd__buf_2
X_1889_ net62 _0895_ VGND VGND VPWR VPWR _0406_ sky130_fd_sc_hd__nor2_1
XPHY_134 VGND VGND VPWR VPWR sky130_fd_sc_hd__decap_3
XPHY_123 VGND VGND VPWR VPWR sky130_fd_sc_hd__decap_3
XPHY_112 VGND VGND VPWR VPWR sky130_fd_sc_hd__decap_3
XPHY_101 VGND VGND VPWR VPWR sky130_fd_sc_hd__decap_3
XPHY_145 VGND VGND VPWR VPWR sky130_fd_sc_hd__decap_3
XFILLER_0_34_253 VGND VGND VPWR VPWR sky130_fd_sc_hd__decap_8
XFILLER_0_57_301 VGND VGND VPWR VPWR sky130_fd_sc_hd__fill_1
XFILLER_0_43_35 VGND VGND VPWR VPWR sky130_fd_sc_hd__fill_1
X_2861_ clknet_leaf_5_clk _0105_ net252 VGND VGND VPWR VPWR regs.lcr\[2\] sky130_fd_sc_hd__dfrtp_4
XPHY_3 VGND VGND VPWR VPWR sky130_fd_sc_hd__decap_3
X_2930_ clknet_leaf_33_clk _0147_ net257 VGND VGND VPWR VPWR rx.state\[2\] sky130_fd_sc_hd__dfrtp_1
XFILLER_0_9_409 VGND VGND VPWR VPWR sky130_fd_sc_hd__fill_1
XFILLER_0_72_348 VGND VGND VPWR VPWR sky130_fd_sc_hd__decap_3
X_1674_ net101 net159 VGND VGND VPWR VPWR _0192_ sky130_fd_sc_hd__nor2_1
X_1812_ _0855_ _0869_ VGND VGND VPWR VPWR _0872_ sky130_fd_sc_hd__nand2_2
X_1743_ net101 _0863_ VGND VGND VPWR VPWR _0258_ sky130_fd_sc_hd__nor2_1
X_2792_ clknet_leaf_41_clk _0450_ net41 VGND VGND VPWR VPWR tx_fifo.fifo\[6\]\[5\]
+ sky130_fd_sc_hd__edfxtp_1
XTAP_698 VGND VPWR sky130_fd_sc_hd__tapvpwrvgnd_1
XTAP_687 VGND VPWR sky130_fd_sc_hd__tapvpwrvgnd_1
XTAP_676 VGND VPWR sky130_fd_sc_hd__tapvpwrvgnd_1
XTAP_665 VGND VPWR sky130_fd_sc_hd__tapvpwrvgnd_1
XTAP_654 VGND VPWR sky130_fd_sc_hd__tapvpwrvgnd_1
XTAP_643 VGND VPWR sky130_fd_sc_hd__tapvpwrvgnd_1
XTAP_632 VGND VPWR sky130_fd_sc_hd__tapvpwrvgnd_1
XTAP_621 VGND VPWR sky130_fd_sc_hd__tapvpwrvgnd_1
XTAP_610 VGND VPWR sky130_fd_sc_hd__tapvpwrvgnd_1
X_2226_ net222 _1108_ VGND VGND VPWR VPWR _0076_ sky130_fd_sc_hd__nor2_1
X_2157_ tx_fifo.fifo\[0\]\[2\] _0997_ _0999_ tx_fifo.fifo\[13\]\[2\] VGND VGND VPWR
+ VPWR _1052_ sky130_fd_sc_hd__a22oi_1
XFILLER_0_16_3 VPWR VGND VPWR VGND sky130_ef_sc_hd__decap_12
X_2088_ rx.shift_reg\[0\] net310 _0987_ VGND VGND VPWR VPWR _0059_ sky130_fd_sc_hd__mux2_1
XFILLER_0_75_142 VPWR VGND VPWR VGND sky130_ef_sc_hd__decap_12
XFILLER_0_48_389 VGND VGND VPWR VPWR sky130_fd_sc_hd__decap_6
XFILLER_0_66_197 VGND VGND VPWR VPWR sky130_fd_sc_hd__decap_8
XFILLER_0_66_153 VGND VGND VPWR VPWR sky130_fd_sc_hd__decap_3
XFILLER_0_39_312 VPWR VGND VPWR VGND sky130_ef_sc_hd__decap_12
XFILLER_0_13_38 VPWR VGND VPWR VGND sky130_ef_sc_hd__decap_12
X_1390_ _0585_ net212 _0628_ VGND VGND VPWR VPWR _0629_ sky130_fd_sc_hd__or3b_1
XFILLER_0_77_429 VPWR VGND VPWR VGND sky130_ef_sc_hd__decap_12
X_2011_ _0928_ _0931_ net220 VGND VGND VPWR VPWR _0039_ sky130_fd_sc_hd__a21oi_1
XFILLER_0_72_134 VGND VGND VPWR VPWR sky130_fd_sc_hd__decap_6
XFILLER_0_72_123 VGND VGND VPWR VPWR sky130_fd_sc_hd__decap_3
X_2844_ clknet_leaf_5_clk _0120_ net248 VGND VGND VPWR VPWR net32 sky130_fd_sc_hd__dfrtp_4
X_2913_ clknet_leaf_35_clk _0062_ net254 VGND VGND VPWR VPWR tx.shift_reg\[4\] sky130_fd_sc_hd__dfrtp_1
Xhold113 tx.baud_cnt\[10\] VGND VGND VPWR VPWR net374 sky130_fd_sc_hd__dlygate4sd3_1
Xhold102 tx.baud_cnt\[15\] VGND VGND VPWR VPWR net363 sky130_fd_sc_hd__dlygate4sd3_1
X_1588_ _0787_ _0792_ _0716_ VGND VGND VPWR VPWR _0793_ sky130_fd_sc_hd__o21ai_1
X_2775_ clknet_leaf_3_clk _0377_ _0007_ VGND VGND VPWR VPWR tx_fifo.fifo\[15\]\[4\]
+ sky130_fd_sc_hd__edfxtp_1
X_1726_ net113 net154 VGND VGND VPWR VPWR _0254_ sky130_fd_sc_hd__nor2_1
X_1657_ regs.rx_data\[2\] net125 VGND VGND VPWR VPWR _0850_ sky130_fd_sc_hd__nand2_1
XFILLER_0_13_289 VGND VGND VPWR VPWR sky130_fd_sc_hd__decap_6
XTAP_495 VGND VPWR sky130_fd_sc_hd__tapvpwrvgnd_1
XTAP_484 VGND VPWR sky130_fd_sc_hd__tapvpwrvgnd_1
XTAP_473 VGND VPWR sky130_fd_sc_hd__tapvpwrvgnd_1
XTAP_462 VGND VPWR sky130_fd_sc_hd__tapvpwrvgnd_1
XTAP_451 VGND VPWR sky130_fd_sc_hd__tapvpwrvgnd_1
XTAP_440 VGND VPWR sky130_fd_sc_hd__tapvpwrvgnd_1
X_2209_ net390 _1094_ _1090_ VGND VGND VPWR VPWR _1095_ sky130_fd_sc_hd__o21ai_0
XFILLER_0_68_429 VGND VGND VPWR VPWR sky130_fd_sc_hd__decap_3
XFILLER_0_63_167 VGND VGND VPWR VPWR sky130_fd_sc_hd__fill_1
XFILLER_0_48_197 VGND VGND VPWR VPWR sky130_fd_sc_hd__fill_2
XFILLER_0_5_3 VGND VGND VPWR VPWR sky130_fd_sc_hd__fill_2
Xclkbuf_2_0__f_clk clknet_0_clk VGND VGND VPWR VPWR clknet_2_0__leaf_clk sky130_fd_sc_hd__clkbuf_16
XFILLER_0_42_307 VGND VGND VPWR VPWR sky130_fd_sc_hd__fill_1
XFILLER_0_27_337 VGND VGND VPWR VPWR sky130_fd_sc_hd__fill_1
XFILLER_0_27_326 VGND VGND VPWR VPWR sky130_fd_sc_hd__decap_4
X_2560_ clknet_leaf_22_clk _0335_ _0028_ VGND VGND VPWR VPWR rx_fifo.fifo\[1\]\[0\]
+ sky130_fd_sc_hd__edfxtp_1
X_1442_ divisor\[14\] _0578_ divisor\[15\] VGND VGND VPWR VPWR _0663_ sky130_fd_sc_hd__o21ai_1
XFILLER_0_50_395 VGND VGND VPWR VPWR sky130_fd_sc_hd__fill_1
X_1511_ rx_fifo.fifo\[5\]\[6\] net163 _0537_ rx_fifo.fifo\[8\]\[6\] rx_fifo.fifo\[12\]\[6\]
+ net165 VGND VGND VPWR VPWR _0720_ sky130_fd_sc_hd__a222oi_1
X_2491_ _0949_ _0976_ _1237_ net262 VGND VGND VPWR VPWR _1238_ sky130_fd_sc_hd__o31ai_1
X_1373_ tx.baud_cnt\[3\] _0611_ VGND VGND VPWR VPWR _0612_ sky130_fd_sc_hd__xnor2_1
XFILLER_0_4_14 VPWR VGND VPWR VGND sky130_ef_sc_hd__decap_12
XFILLER_0_77_237 VPWR VGND VPWR VGND sky130_ef_sc_hd__decap_12
XFILLER_0_73_421 VPWR VGND VPWR VGND sky130_ef_sc_hd__decap_12
XFILLER_0_45_167 VGND VGND VPWR VPWR sky130_fd_sc_hd__fill_1
XFILLER_0_45_145 VGND VGND VPWR VPWR sky130_fd_sc_hd__fill_2
XFILLER_0_41_351 VGND VGND VPWR VPWR sky130_fd_sc_hd__fill_1
XFILLER_0_33_329 VGND VGND VPWR VPWR sky130_fd_sc_hd__fill_1
XFILLER_0_26_392 VGND VGND VPWR VPWR sky130_fd_sc_hd__decap_8
X_2758_ clknet_leaf_40_clk _0472_ net45 VGND VGND VPWR VPWR tx_fifo.fifo\[3\]\[3\]
+ sky130_fd_sc_hd__edfxtp_1
X_2827_ clknet_leaf_39_clk _0413_ net57 VGND VGND VPWR VPWR tx_fifo.fifo\[10\]\[0\]
+ sky130_fd_sc_hd__edfxtp_1
X_1709_ net104 _0860_ VGND VGND VPWR VPWR _0227_ sky130_fd_sc_hd__nor2_1
X_2689_ clknet_leaf_28_clk _0256_ net93 VGND VGND VPWR VPWR rx_fifo.fifo\[9\]\[8\]
+ sky130_fd_sc_hd__edfxtp_1
XTAP_270 VGND VPWR sky130_fd_sc_hd__tapvpwrvgnd_1
XTAP_281 VGND VPWR sky130_fd_sc_hd__tapvpwrvgnd_1
XTAP_292 VGND VPWR sky130_fd_sc_hd__tapvpwrvgnd_1
Xfanout52 _0629_ VGND VGND VPWR VPWR net52 sky130_fd_sc_hd__buf_2
Xfanout74 _0701_ VGND VGND VPWR VPWR net74 sky130_fd_sc_hd__buf_2
Xfanout96 _0019_ VGND VGND VPWR VPWR net96 sky130_fd_sc_hd__buf_4
Xfanout85 _0028_ VGND VGND VPWR VPWR net85 sky130_fd_sc_hd__buf_4
XFILLER_0_36_167 VGND VGND VPWR VPWR sky130_fd_sc_hd__fill_2
XFILLER_0_36_134 VGND VGND VPWR VPWR sky130_fd_sc_hd__decap_6
Xfanout63 _0886_ VGND VGND VPWR VPWR net63 sky130_fd_sc_hd__buf_2
XFILLER_0_24_329 VGND VGND VPWR VPWR sky130_fd_sc_hd__decap_8
XFILLER_0_19_37 VGND VGND VPWR VPWR sky130_fd_sc_hd__decap_4
XFILLER_0_70_457 VGND VGND VPWR VPWR sky130_fd_sc_hd__decap_6
XFILLER_0_70_413 VGND VGND VPWR VPWR sky130_fd_sc_hd__fill_1
XFILLER_0_67_281 VPWR VGND VPWR VGND sky130_ef_sc_hd__decap_12
XFILLER_0_55_421 VGND VGND VPWR VPWR sky130_fd_sc_hd__decap_3
X_2612_ clknet_leaf_17_clk _0311_ net80 VGND VGND VPWR VPWR rx_fifo.fifo\[4\]\[8\]
+ sky130_fd_sc_hd__edfxtp_1
X_1991_ net227 _0914_ _0915_ VGND VGND VPWR VPWR _0035_ sky130_fd_sc_hd__o21a_1
XFILLER_0_2_212 VGND VGND VPWR VPWR sky130_fd_sc_hd__fill_2
XFILLER_0_15_329 VGND VGND VPWR VPWR sky130_fd_sc_hd__decap_6
X_1425_ tx.baud_cnt\[1\] net277 VGND VGND VPWR VPWR _0651_ sky130_fd_sc_hd__xnor2_1
X_2543_ clknet_leaf_17_clk _0231_ net89 VGND VGND VPWR VPWR rx_fifo.fifo\[11\]\[5\]
+ sky130_fd_sc_hd__edfxtp_1
X_2474_ net14 net312 _1135_ VGND VGND VPWR VPWR _0142_ sky130_fd_sc_hd__mux2_1
X_1356_ divisor\[8\] divisor\[9\] net214 _0569_ divisor\[10\] VGND VGND VPWR VPWR
+ _0595_ sky130_fd_sc_hd__o41ai_1
X_1287_ _0519_ _0528_ VGND VGND VPWR VPWR _0529_ sky130_fd_sc_hd__nor2_1
XFILLER_0_61_446 VGND VGND VPWR VPWR sky130_fd_sc_hd__fill_2
XFILLER_0_33_137 VPWR VGND VPWR VGND sky130_ef_sc_hd__decap_12
XFILLER_0_18_178 VGND VGND VPWR VPWR sky130_fd_sc_hd__fill_1
Xfanout242 net246 VGND VGND VPWR VPWR net242 sky130_fd_sc_hd__clkbuf_2
Xfanout220 regs.tx_fifo_clear VGND VGND VPWR VPWR net220 sky130_fd_sc_hd__clkbuf_4
Xfanout231 tx_fifo.head\[0\] VGND VGND VPWR VPWR net231 sky130_fd_sc_hd__clkbuf_4
Xfanout253 net256 VGND VGND VPWR VPWR net253 sky130_fd_sc_hd__clkbuf_4
XFILLER_0_52_435 VGND VGND VPWR VPWR sky130_fd_sc_hd__fill_1
XFILLER_0_49_281 VGND VGND VPWR VPWR sky130_fd_sc_hd__fill_1
XFILLER_0_32_192 VGND VGND VPWR VPWR sky130_fd_sc_hd__decap_4
XFILLER_0_20_365 VGND VGND VPWR VPWR sky130_fd_sc_hd__decap_6
XFILLER_0_20_398 VGND VGND VPWR VPWR sky130_fd_sc_hd__fill_1
X_2190_ rx_fifo.tail\[2\] _0840_ _1081_ VGND VGND VPWR VPWR _0067_ sky130_fd_sc_hd__o21a_1
XFILLER_0_1_15 VPWR VGND VPWR VGND sky130_ef_sc_hd__decap_12
X_1974_ net73 _0908_ VGND VGND VPWR VPWR _0499_ sky130_fd_sc_hd__nor2_1
XFILLER_0_23_192 VGND VGND VPWR VPWR sky130_fd_sc_hd__decap_8
XFILLER_0_11_93 VGND VGND VPWR VPWR sky130_fd_sc_hd__decap_4
XFILLER_0_15_104 VGND VGND VPWR VPWR sky130_fd_sc_hd__fill_1
X_1408_ net52 _0635_ _0642_ VGND VGND VPWR VPWR _0358_ sky130_fd_sc_hd__nor3_1
Xhold17 regs.dlh\[0\] VGND VGND VPWR VPWR net278 sky130_fd_sc_hd__dlygate4sd3_1
X_2457_ regs.mcr_reg\[7\] _0730_ _0731_ net235 _0732_ VGND VGND VPWR VPWR _1219_ sky130_fd_sc_hd__a221o_1
XFILLER_0_46_3 VPWR VGND VPWR VGND sky130_ef_sc_hd__decap_12
Xhold39 regs.mcr_reg\[5\] VGND VGND VPWR VPWR net300 sky130_fd_sc_hd__dlygate4sd3_1
X_2526_ net124 net159 net180 VGND VGND VPWR VPWR _0031_ sky130_fd_sc_hd__nor3_1
Xhold28 _0057_ VGND VGND VPWR VPWR net289 sky130_fd_sc_hd__dlygate4sd3_1
XFILLER_0_11_365 VGND VGND VPWR VPWR sky130_fd_sc_hd__fill_1
X_2388_ net34 _1185_ VGND VGND VPWR VPWR _1186_ sky130_fd_sc_hd__nor2_1
X_1339_ divisor\[12\] divisor\[13\] divisor\[11\] net160 VGND VGND VPWR VPWR _0578_
+ sky130_fd_sc_hd__or4_4
XFILLER_0_61_243 VGND VGND VPWR VPWR sky130_fd_sc_hd__fill_1
XFILLER_0_46_295 VGND VGND VPWR VPWR sky130_fd_sc_hd__decap_8
XFILLER_0_61_276 VGND VGND VPWR VPWR sky130_fd_sc_hd__fill_1
XFILLER_0_32_15 VGND VGND VPWR VPWR sky130_fd_sc_hd__decap_8
X_1690_ net117 net157 VGND VGND VPWR VPWR _0223_ sky130_fd_sc_hd__nor2_1
Xmax_cap239 _0728_ VGND VGND VPWR VPWR net239 sky130_fd_sc_hd__buf_2
XFILLER_0_40_427 VGND VGND VPWR VPWR sky130_fd_sc_hd__decap_8
Xmax_cap206 _0890_ VGND VGND VPWR VPWR net206 sky130_fd_sc_hd__buf_1
Xmax_cap217 _0512_ VGND VGND VPWR VPWR net217 sky130_fd_sc_hd__clkbuf_1
X_2311_ _1109_ _1117_ _0628_ VGND VGND VPWR VPWR _1144_ sky130_fd_sc_hd__o21bai_1
X_2242_ parity_en _0991_ _1116_ VGND VGND VPWR VPWR _1124_ sky130_fd_sc_hd__nand3_1
XFILLER_0_20_151 VGND VGND VPWR VPWR sky130_fd_sc_hd__decap_4
XFILLER_0_73_55 VGND VGND VPWR VPWR sky130_fd_sc_hd__fill_1
X_2173_ _1061_ _1063_ _1065_ net138 VGND VGND VPWR VPWR _1067_ sky130_fd_sc_hd__nand4_1
X_1957_ net209 _0904_ VGND VGND VPWR VPWR _0906_ sky130_fd_sc_hd__nand2_4
XFILLER_0_16_402 VGND VGND VPWR VPWR sky130_fd_sc_hd__fill_1
Xoutput18 net18 VGND VGND VPWR VPWR dtr sky130_fd_sc_hd__buf_2
Xoutput29 net29 VGND VGND VPWR VPWR rdata[5] sky130_fd_sc_hd__buf_2
X_2509_ net227 _0914_ net225 VGND VGND VPWR VPWR _1246_ sky130_fd_sc_hd__a21oi_1
XFILLER_0_11_140 VPWR VGND VPWR VGND sky130_ef_sc_hd__decap_12
X_1888_ net65 _0895_ VGND VGND VPWR VPWR _0407_ sky130_fd_sc_hd__nor2_1
XPHY_146 VGND VGND VPWR VPWR sky130_fd_sc_hd__decap_3
XPHY_135 VGND VGND VPWR VPWR sky130_fd_sc_hd__decap_3
XPHY_124 VGND VGND VPWR VPWR sky130_fd_sc_hd__decap_3
XPHY_113 VGND VGND VPWR VPWR sky130_fd_sc_hd__decap_3
XPHY_102 VGND VGND VPWR VPWR sky130_fd_sc_hd__decap_3
Xclkbuf_leaf_36_clk clknet_2_1__leaf_clk VGND VGND VPWR VPWR clknet_leaf_36_clk sky130_fd_sc_hd__clkbuf_16
XFILLER_0_69_151 VPWR VGND VPWR VGND sky130_ef_sc_hd__decap_12
Xclkbuf_leaf_27_clk clknet_2_3__leaf_clk VGND VGND VPWR VPWR clknet_leaf_27_clk sky130_fd_sc_hd__clkbuf_16
XFILLER_0_69_173 VGND VGND VPWR VPWR sky130_fd_sc_hd__fill_1
XFILLER_0_57_357 VGND VGND VPWR VPWR sky130_fd_sc_hd__fill_2
X_1811_ net101 _0871_ VGND VGND VPWR VPWR _0324_ sky130_fd_sc_hd__nor2_1
X_2860_ clknet_leaf_5_clk _0106_ net252 VGND VGND VPWR VPWR data_bits\[1\] sky130_fd_sc_hd__dfstp_2
XPHY_4 VGND VGND VPWR VPWR sky130_fd_sc_hd__decap_3
X_2791_ clknet_leaf_43_clk _0449_ _0005_ VGND VGND VPWR VPWR tx_fifo.fifo\[6\]\[4\]
+ sky130_fd_sc_hd__edfxtp_1
X_1673_ net103 _0854_ VGND VGND VPWR VPWR _0194_ sky130_fd_sc_hd__nor2_1
XTAP_600 VGND VPWR sky130_fd_sc_hd__tapvpwrvgnd_1
X_1742_ net104 net153 VGND VGND VPWR VPWR _0260_ sky130_fd_sc_hd__nor2_1
XFILLER_0_25_298 VPWR VGND VPWR VGND sky130_ef_sc_hd__decap_12
XFILLER_0_0_343 VPWR VGND VPWR VGND sky130_ef_sc_hd__decap_12
XFILLER_0_0_321 VPWR VGND VPWR VGND sky130_ef_sc_hd__decap_12
XFILLER_0_7_69 VPWR VGND VPWR VGND sky130_ef_sc_hd__decap_12
XFILLER_0_13_405 VGND VGND VPWR VPWR sky130_fd_sc_hd__fill_1
XTAP_699 VGND VPWR sky130_fd_sc_hd__tapvpwrvgnd_1
XTAP_688 VGND VPWR sky130_fd_sc_hd__tapvpwrvgnd_1
XTAP_677 VGND VPWR sky130_fd_sc_hd__tapvpwrvgnd_1
XTAP_666 VGND VPWR sky130_fd_sc_hd__tapvpwrvgnd_1
XTAP_655 VGND VPWR sky130_fd_sc_hd__tapvpwrvgnd_1
XTAP_644 VGND VPWR sky130_fd_sc_hd__tapvpwrvgnd_1
XTAP_633 VGND VPWR sky130_fd_sc_hd__tapvpwrvgnd_1
XTAP_622 VGND VPWR sky130_fd_sc_hd__tapvpwrvgnd_1
XTAP_611 VGND VPWR sky130_fd_sc_hd__tapvpwrvgnd_1
X_2225_ net379 _1092_ VGND VGND VPWR VPWR _1108_ sky130_fd_sc_hd__xor2_1
XFILLER_0_0_365 VPWR VGND VPWR VGND sky130_ef_sc_hd__decap_12
XFILLER_0_75_154 VPWR VGND VPWR VGND sky130_ef_sc_hd__decap_12
XFILLER_0_75_110 VGND VGND VPWR VPWR sky130_fd_sc_hd__fill_2
Xclkbuf_leaf_18_clk clknet_2_3__leaf_clk VGND VGND VPWR VPWR clknet_leaf_18_clk sky130_fd_sc_hd__clkbuf_16
XFILLER_0_48_357 VGND VGND VPWR VPWR sky130_fd_sc_hd__fill_1
X_2156_ tx_fifo.fifo\[14\]\[2\] _1004_ _1009_ tx_fifo.fifo\[15\]\[2\] VGND VGND VPWR
+ VPWR _1051_ sky130_fd_sc_hd__a22oi_1
X_2087_ rx.shift_reg\[1\] net284 _0987_ VGND VGND VPWR VPWR _0058_ sky130_fd_sc_hd__mux2_1
XFILLER_0_8_421 VPWR VGND VPWR VGND sky130_ef_sc_hd__decap_12
X_2989_ clknet_leaf_11_clk _0371_ net245 VGND VGND VPWR VPWR tx.baud_cnt\[8\] sky130_fd_sc_hd__dfrtp_2
XFILLER_0_71_393 VGND VGND VPWR VPWR sky130_fd_sc_hd__decap_6
XFILLER_0_71_371 VPWR VGND VPWR VGND sky130_ef_sc_hd__decap_12
XFILLER_0_31_268 VPWR VGND VPWR VGND sky130_ef_sc_hd__decap_12
XFILLER_0_47_390 VGND VGND VPWR VPWR sky130_fd_sc_hd__fill_2
XFILLER_0_39_324 VGND VGND VPWR VPWR sky130_fd_sc_hd__fill_2
XFILLER_0_22_257 VGND VGND VPWR VPWR sky130_fd_sc_hd__decap_8
X_2010_ _0918_ _0929_ _0930_ _0919_ VGND VGND VPWR VPWR _0931_ sky130_fd_sc_hd__a22oi_1
X_2912_ clknet_leaf_35_clk _0063_ net253 VGND VGND VPWR VPWR tx.shift_reg\[3\] sky130_fd_sc_hd__dfrtp_1
XFILLER_0_72_157 VGND VGND VPWR VPWR sky130_fd_sc_hd__decap_6
XFILLER_0_70_89 VGND VGND VPWR VPWR sky130_fd_sc_hd__decap_8
X_2843_ clknet_leaf_15_clk _0121_ net250 VGND VGND VPWR VPWR net18 sky130_fd_sc_hd__dfrtp_2
XFILLER_0_53_393 VGND VGND VPWR VPWR sky130_fd_sc_hd__decap_3
X_1725_ net115 net154 VGND VGND VPWR VPWR _0255_ sky130_fd_sc_hd__nor2_1
XFILLER_0_5_457 VGND VGND VPWR VPWR sky130_fd_sc_hd__fill_2
X_2774_ clknet_leaf_42_clk _0376_ net43 VGND VGND VPWR VPWR tx_fifo.fifo\[15\]\[3\]
+ sky130_fd_sc_hd__edfxtp_1
Xhold114 rx.baud_cnt\[1\] VGND VGND VPWR VPWR net375 sky130_fd_sc_hd__dlygate4sd3_1
X_1587_ _0788_ _0789_ net130 _0791_ VGND VGND VPWR VPWR _0792_ sky130_fd_sc_hd__nand4_1
X_1656_ net210 net107 VGND VGND VPWR VPWR _0185_ sky130_fd_sc_hd__nor2_1
Xhold103 rx.baud_cnt\[7\] VGND VGND VPWR VPWR net364 sky130_fd_sc_hd__dlygate4sd3_1
Xclkbuf_leaf_7_clk clknet_2_2__leaf_clk VGND VGND VPWR VPWR clknet_leaf_7_clk sky130_fd_sc_hd__clkbuf_16
XTAP_441 VGND VPWR sky130_fd_sc_hd__tapvpwrvgnd_1
XTAP_430 VGND VPWR sky130_fd_sc_hd__tapvpwrvgnd_1
XFILLER_0_0_195 VGND VGND VPWR VPWR sky130_fd_sc_hd__fill_1
XFILLER_0_68_419 VGND VGND VPWR VPWR sky130_fd_sc_hd__fill_1
XTAP_496 VGND VPWR sky130_fd_sc_hd__tapvpwrvgnd_1
XTAP_485 VGND VPWR sky130_fd_sc_hd__tapvpwrvgnd_1
XTAP_474 VGND VPWR sky130_fd_sc_hd__tapvpwrvgnd_1
XTAP_463 VGND VPWR sky130_fd_sc_hd__tapvpwrvgnd_1
XTAP_452 VGND VPWR sky130_fd_sc_hd__tapvpwrvgnd_1
X_2208_ rx_fifo.count\[0\] rx_fifo.count\[2\] rx_fifo.count\[1\] rx_fifo.count\[3\]
+ VGND VGND VPWR VPWR _1094_ sky130_fd_sc_hd__o31a_1
X_2139_ tx_fifo.fifo\[12\]\[4\] net197 _1006_ tx_fifo.fifo\[4\]\[4\] VGND VGND VPWR
+ VPWR _1036_ sky130_fd_sc_hd__a22oi_2
XFILLER_0_51_308 VGND VGND VPWR VPWR sky130_fd_sc_hd__decap_4
XFILLER_0_24_27 VGND VGND VPWR VPWR sky130_fd_sc_hd__fill_1
XFILLER_0_40_15 VGND VGND VPWR VPWR sky130_fd_sc_hd__decap_3
XFILLER_0_35_393 VPWR VGND VPWR VGND sky130_ef_sc_hd__decap_12
XFILLER_0_50_330 VGND VGND VPWR VPWR sky130_fd_sc_hd__decap_6
X_1441_ net273 _0658_ _0662_ VGND VGND VPWR VPWR _0164_ sky130_fd_sc_hd__a21oi_1
XFILLER_0_49_57 VPWR VGND VPWR VGND sky130_ef_sc_hd__decap_12
X_1510_ _0717_ _0718_ VGND VGND VPWR VPWR _0719_ sky130_fd_sc_hd__nand2_1
X_2490_ _0947_ _0971_ _0975_ _1235_ VGND VGND VPWR VPWR _1237_ sky130_fd_sc_hd__o22ai_1
X_1372_ _0567_ _0610_ VGND VGND VPWR VPWR _0611_ sky130_fd_sc_hd__nand2_1
XFILLER_0_65_78 VGND VGND VPWR VPWR sky130_fd_sc_hd__decap_4
XFILLER_0_4_26 VGND VGND VPWR VPWR sky130_fd_sc_hd__fill_2
XFILLER_0_77_249 VGND VGND VPWR VPWR sky130_fd_sc_hd__decap_3
XFILLER_0_73_433 VPWR VGND VPWR VGND sky130_ef_sc_hd__decap_12
XFILLER_0_18_338 VGND VGND VPWR VPWR sky130_fd_sc_hd__fill_1
XFILLER_0_76_3 VPWR VGND VPWR VGND sky130_ef_sc_hd__decap_12
X_1708_ net105 _0860_ VGND VGND VPWR VPWR _0228_ sky130_fd_sc_hd__nor2_1
X_2688_ clknet_leaf_38_clk _0255_ net93 VGND VGND VPWR VPWR rx_fifo.fifo\[9\]\[7\]
+ sky130_fd_sc_hd__edfxtp_1
XFILLER_0_30_81 VGND VGND VPWR VPWR sky130_fd_sc_hd__decap_3
X_2826_ clknet_leaf_40_clk _0428_ net37 VGND VGND VPWR VPWR tx_fifo.fifo\[9\]\[7\]
+ sky130_fd_sc_hd__edfxtp_1
X_2757_ clknet_leaf_39_clk _0471_ net45 VGND VGND VPWR VPWR tx_fifo.fifo\[3\]\[2\]
+ sky130_fd_sc_hd__edfxtp_1
XFILLER_0_41_396 VPWR VGND VPWR VGND sky130_ef_sc_hd__decap_12
X_1639_ rx.dr _0837_ VGND VGND VPWR VPWR _0839_ sky130_fd_sc_hd__nand2_2
XTAP_260 VGND VPWR sky130_fd_sc_hd__tapvpwrvgnd_1
XTAP_271 VGND VPWR sky130_fd_sc_hd__tapvpwrvgnd_1
XTAP_282 VGND VPWR sky130_fd_sc_hd__tapvpwrvgnd_1
XTAP_293 VGND VPWR sky130_fd_sc_hd__tapvpwrvgnd_1
Xfanout53 _0629_ VGND VGND VPWR VPWR net53 sky130_fd_sc_hd__clkbuf_2
XFILLER_0_64_455 VGND VGND VPWR VPWR sky130_fd_sc_hd__decap_8
Xfanout97 _0020_ VGND VGND VPWR VPWR net97 sky130_fd_sc_hd__buf_4
Xfanout86 net87 VGND VGND VPWR VPWR net86 sky130_fd_sc_hd__buf_4
Xfanout64 _0885_ VGND VGND VPWR VPWR net64 sky130_fd_sc_hd__clkbuf_4
XFILLER_0_17_360 VGND VGND VPWR VPWR sky130_fd_sc_hd__fill_2
Xfanout75 _0988_ VGND VGND VPWR VPWR net75 sky130_fd_sc_hd__buf_2
XFILLER_0_10_29 VPWR VGND VPWR VGND sky130_ef_sc_hd__decap_12
XFILLER_0_17_393 VGND VGND VPWR VPWR sky130_fd_sc_hd__decap_3
XFILLER_0_19_49 VGND VGND VPWR VPWR sky130_fd_sc_hd__decap_4
XFILLER_0_67_293 VGND VGND VPWR VPWR sky130_fd_sc_hd__decap_4
XFILLER_0_67_271 VGND VGND VPWR VPWR sky130_fd_sc_hd__decap_8
XFILLER_0_51_36 VGND VGND VPWR VPWR sky130_fd_sc_hd__decap_4
XFILLER_0_27_113 VGND VGND VPWR VPWR sky130_fd_sc_hd__fill_2
X_1990_ net227 _0914_ net220 VGND VGND VPWR VPWR _0915_ sky130_fd_sc_hd__a21oi_1
X_2611_ clknet_leaf_20_clk _0310_ net80 VGND VGND VPWR VPWR rx_fifo.fifo\[4\]\[7\]
+ sky130_fd_sc_hd__edfxtp_1
X_2542_ clknet_leaf_18_clk _0230_ net89 VGND VGND VPWR VPWR rx_fifo.fifo\[11\]\[4\]
+ sky130_fd_sc_hd__edfxtp_1
X_1424_ net53 _0630_ net369 VGND VGND VPWR VPWR _0365_ sky130_fd_sc_hd__nor3_1
X_1355_ _0577_ _0593_ VGND VGND VPWR VPWR _0594_ sky130_fd_sc_hd__nor2_1
X_2473_ _0902_ net54 VGND VGND VPWR VPWR _0460_ sky130_fd_sc_hd__nor2_1
X_1286_ rx_fifo.head\[0\] rx_fifo.head\[1\] VGND VGND VPWR VPWR _0528_ sky130_fd_sc_hd__nand2b_1
XFILLER_0_73_274 VGND VGND VPWR VPWR sky130_fd_sc_hd__decap_6
XFILLER_0_46_400 VPWR VGND VPWR VGND sky130_ef_sc_hd__decap_12
XFILLER_0_33_105 VGND VGND VPWR VPWR sky130_fd_sc_hd__decap_4
XFILLER_0_41_182 VGND VGND VPWR VPWR sky130_fd_sc_hd__fill_1
XFILLER_0_33_149 VGND VGND VPWR VPWR sky130_fd_sc_hd__decap_8
X_2809_ clknet_leaf_3_clk _0443_ _0003_ VGND VGND VPWR VPWR tx_fifo.fifo\[7\]\[6\]
+ sky130_fd_sc_hd__edfxtp_1
XFILLER_0_26_190 VGND VGND VPWR VPWR sky130_fd_sc_hd__decap_6
XFILLER_0_14_363 VGND VGND VPWR VPWR sky130_fd_sc_hd__fill_1
Xfanout243 net246 VGND VGND VPWR VPWR net243 sky130_fd_sc_hd__clkbuf_4
Xfanout221 regs.rx_fifo_clear VGND VGND VPWR VPWR net221 sky130_fd_sc_hd__clkbuf_4
Xfanout210 _0841_ VGND VGND VPWR VPWR net210 sky130_fd_sc_hd__buf_4
XFILLER_0_1_290 VGND VGND VPWR VPWR sky130_fd_sc_hd__fill_2
Xfanout232 rx.state\[2\] VGND VGND VPWR VPWR net232 sky130_fd_sc_hd__buf_2
Xfanout254 net256 VGND VGND VPWR VPWR net254 sky130_fd_sc_hd__clkbuf_4
XFILLER_0_64_296 VGND VGND VPWR VPWR sky130_fd_sc_hd__fill_2
XFILLER_0_1_27 VGND VGND VPWR VPWR sky130_fd_sc_hd__decap_4
XFILLER_0_62_79 VGND VGND VPWR VPWR sky130_fd_sc_hd__decap_4
XFILLER_0_55_241 VGND VGND VPWR VPWR sky130_fd_sc_hd__fill_1
XFILLER_0_47_219 VGND VGND VPWR VPWR sky130_fd_sc_hd__fill_2
X_1973_ _0892_ _0904_ VGND VGND VPWR VPWR _0908_ sky130_fd_sc_hd__nand2_4
X_2525_ net14 net235 _1133_ VGND VGND VPWR VPWR _0156_ sky130_fd_sc_hd__mux2_1
X_1407_ tx.baud_cnt\[9\] tx.baud_cnt\[8\] _0633_ net374 VGND VGND VPWR VPWR _0642_
+ sky130_fd_sc_hd__a31oi_1
X_1338_ divisor\[12\] divisor\[11\] net214 net160 VGND VGND VPWR VPWR _0577_ sky130_fd_sc_hd__nor4_1
X_2456_ _1207_ _1217_ _0714_ VGND VGND VPWR VPWR _1218_ sky130_fd_sc_hd__a21oi_1
Xhold18 regs.tx_data\[6\] VGND VGND VPWR VPWR net279 sky130_fd_sc_hd__dlygate4sd3_1
Xhold29 regs.rx_data\[4\] VGND VGND VPWR VPWR net290 sky130_fd_sc_hd__dlygate4sd3_1
X_2387_ _1018_ _1184_ VGND VGND VPWR VPWR _1185_ sky130_fd_sc_hd__xnor2_1
X_1269_ tx_fifo.count\[4\] _0513_ VGND VGND VPWR VPWR net34 sky130_fd_sc_hd__nor2_4
XFILLER_0_46_285 VGND VGND VPWR VPWR sky130_fd_sc_hd__decap_6
XFILLER_0_34_414 VGND VGND VPWR VPWR sky130_fd_sc_hd__decap_6
XFILLER_0_14_171 VPWR VGND VPWR VGND sky130_ef_sc_hd__decap_12
XFILLER_0_37_285 VGND VGND VPWR VPWR sky130_fd_sc_hd__decap_6
XFILLER_0_25_403 VGND VGND VPWR VPWR sky130_fd_sc_hd__decap_8
Xmax_cap207 _0890_ VGND VGND VPWR VPWR net207 sky130_fd_sc_hd__clkbuf_2
XFILLER_0_20_141 VGND VGND VPWR VPWR sky130_fd_sc_hd__decap_6
X_2172_ tx_fifo.fifo\[5\]\[1\] net198 net197 tx_fifo.fifo\[12\]\[1\] _1004_ tx_fifo.fifo\[14\]\[1\]
+ VGND VGND VPWR VPWR _1066_ sky130_fd_sc_hd__a222oi_1
X_2310_ _1120_ _1141_ _1142_ VGND VGND VPWR VPWR _1143_ sky130_fd_sc_hd__nand3_1
X_2241_ tx.state\[1\] _0628_ _1113_ VGND VGND VPWR VPWR _1123_ sky130_fd_sc_hd__nor3b_1
XFILLER_0_43_244 VGND VGND VPWR VPWR sky130_fd_sc_hd__fill_2
XFILLER_0_43_200 VPWR VGND VPWR VGND sky130_ef_sc_hd__decap_12
X_1887_ net66 _0895_ VGND VGND VPWR VPWR _0408_ sky130_fd_sc_hd__nor2_1
X_1956_ net60 _0905_ VGND VGND VPWR VPWR _0469_ sky130_fd_sc_hd__nor2_1
X_2508_ _0919_ _1245_ _1244_ net220 VGND VGND VPWR VPWR _0150_ sky130_fd_sc_hd__a211oi_1
Xoutput19 net19 VGND VGND VPWR VPWR framing_err sky130_fd_sc_hd__clkbuf_4
XFILLER_0_11_152 VPWR VGND VPWR VGND sky130_ef_sc_hd__decap_12
X_2439_ tx.state\[2\] tx.state\[0\] tx.state\[1\] VGND VGND VPWR VPWR _1203_ sky130_fd_sc_hd__a21oi_1
XPHY_147 VGND VGND VPWR VPWR sky130_fd_sc_hd__decap_3
XPHY_136 VGND VGND VPWR VPWR sky130_fd_sc_hd__decap_3
XFILLER_0_66_303 VGND VGND VPWR VPWR sky130_fd_sc_hd__decap_4
XPHY_125 VGND VGND VPWR VPWR sky130_fd_sc_hd__decap_3
XPHY_114 VGND VGND VPWR VPWR sky130_fd_sc_hd__decap_3
XPHY_103 VGND VGND VPWR VPWR sky130_fd_sc_hd__decap_3
XFILLER_0_34_277 VGND VGND VPWR VPWR sky130_fd_sc_hd__fill_1
XFILLER_0_34_222 VGND VGND VPWR VPWR sky130_fd_sc_hd__decap_6
XFILLER_0_69_163 VGND VGND VPWR VPWR sky130_fd_sc_hd__decap_4
XFILLER_0_69_141 VGND VGND VPWR VPWR sky130_fd_sc_hd__fill_1
XFILLER_0_43_15 VPWR VGND VPWR VGND sky130_ef_sc_hd__decap_12
Xmax_cap94 _0017_ VGND VGND VPWR VPWR net94 sky130_fd_sc_hd__buf_1
XPHY_5 VGND VGND VPWR VPWR sky130_fd_sc_hd__decap_3
Xmax_cap50 _0014_ VGND VGND VPWR VPWR net50 sky130_fd_sc_hd__buf_2
X_1810_ net103 net147 VGND VGND VPWR VPWR _0326_ sky130_fd_sc_hd__nor2_1
X_1741_ net106 net153 VGND VGND VPWR VPWR _0261_ sky130_fd_sc_hd__nor2_1
XFILLER_0_4_138 VGND VGND VPWR VPWR sky130_fd_sc_hd__fill_2
XFILLER_0_4_105 VGND VGND VPWR VPWR sky130_fd_sc_hd__fill_2
X_2790_ clknet_leaf_40_clk _0448_ net41 VGND VGND VPWR VPWR tx_fifo.fifo\[6\]\[3\]
+ sky130_fd_sc_hd__edfxtp_1
XFILLER_0_68_67 VGND VGND VPWR VPWR sky130_fd_sc_hd__decap_3
X_1672_ net105 net159 VGND VGND VPWR VPWR _0195_ sky130_fd_sc_hd__nor2_1
XTAP_634 VGND VPWR sky130_fd_sc_hd__tapvpwrvgnd_1
XTAP_623 VGND VPWR sky130_fd_sc_hd__tapvpwrvgnd_1
XTAP_612 VGND VPWR sky130_fd_sc_hd__tapvpwrvgnd_1
XTAP_601 VGND VPWR sky130_fd_sc_hd__tapvpwrvgnd_1
XFILLER_0_0_377 VPWR VGND VPWR VGND sky130_ef_sc_hd__decap_12
XFILLER_0_0_355 VGND VGND VPWR VPWR sky130_fd_sc_hd__decap_8
XFILLER_0_0_333 VGND VGND VPWR VPWR sky130_fd_sc_hd__decap_3
XFILLER_0_7_15 VGND VGND VPWR VPWR sky130_fd_sc_hd__decap_3
XTAP_689 VGND VPWR sky130_fd_sc_hd__tapvpwrvgnd_1
XTAP_678 VGND VPWR sky130_fd_sc_hd__tapvpwrvgnd_1
XTAP_667 VGND VPWR sky130_fd_sc_hd__tapvpwrvgnd_1
XTAP_656 VGND VPWR sky130_fd_sc_hd__tapvpwrvgnd_1
XTAP_645 VGND VPWR sky130_fd_sc_hd__tapvpwrvgnd_1
X_2224_ _1104_ _1107_ net222 VGND VGND VPWR VPWR _0075_ sky130_fd_sc_hd__a21oi_1
X_2155_ tx_fifo.fifo\[10\]\[2\] net385 VGND VGND VPWR VPWR _1050_ sky130_fd_sc_hd__nand2_1
XFILLER_0_75_166 VGND VGND VPWR VPWR sky130_fd_sc_hd__fill_2
XFILLER_0_75_122 VGND VGND VPWR VPWR sky130_fd_sc_hd__decap_4
XFILLER_0_8_411 VGND VGND VPWR VPWR sky130_fd_sc_hd__decap_8
XFILLER_0_8_433 VPWR VGND VPWR VGND sky130_ef_sc_hd__decap_12
X_2086_ rx.shift_reg\[2\] net288 _0987_ VGND VGND VPWR VPWR _0057_ sky130_fd_sc_hd__mux2_1
XFILLER_0_71_383 VGND VGND VPWR VPWR sky130_fd_sc_hd__decap_8
X_2988_ clknet_leaf_11_clk _0370_ net245 VGND VGND VPWR VPWR tx.baud_cnt\[7\] sky130_fd_sc_hd__dfrtp_1
X_1939_ net61 _0902_ VGND VGND VPWR VPWR _0453_ sky130_fd_sc_hd__nor2_1
XFILLER_0_31_225 VPWR VGND VPWR VGND sky130_ef_sc_hd__decap_12
XFILLER_0_16_233 VPWR VGND VPWR VGND sky130_ef_sc_hd__decap_12
XFILLER_0_66_188 VGND VGND VPWR VPWR sky130_fd_sc_hd__decap_8
XFILLER_0_62_361 VGND VGND VPWR VPWR sky130_fd_sc_hd__decap_3
XFILLER_0_54_317 VGND VGND VPWR VPWR sky130_fd_sc_hd__decap_4
XFILLER_0_10_409 VGND VGND VPWR VPWR sky130_fd_sc_hd__fill_2
XFILLER_0_57_166 VGND VGND VPWR VPWR sky130_fd_sc_hd__fill_2
XFILLER_0_57_111 VGND VGND VPWR VPWR sky130_fd_sc_hd__fill_1
XFILLER_0_54_69 VGND VGND VPWR VPWR sky130_fd_sc_hd__fill_1
X_2911_ clknet_leaf_34_clk net276 net253 VGND VGND VPWR VPWR tx.shift_reg\[2\] sky130_fd_sc_hd__dfrtp_1
Xhold115 tx.baud_cnt\[13\] VGND VGND VPWR VPWR net376 sky130_fd_sc_hd__dlygate4sd3_1
Xhold104 rx.baud_cnt\[2\] VGND VGND VPWR VPWR net365 sky130_fd_sc_hd__dlygate4sd3_1
X_2842_ clknet_leaf_16_clk _0140_ net248 VGND VGND VPWR VPWR regs.err_pending sky130_fd_sc_hd__dfrtp_1
X_1724_ net118 net154 VGND VGND VPWR VPWR _0256_ sky130_fd_sc_hd__nor2_1
X_2773_ clknet_leaf_3_clk _0375_ _0007_ VGND VGND VPWR VPWR tx_fifo.fifo\[15\]\[2\]
+ sky130_fd_sc_hd__edfxtp_1
XFILLER_0_5_447 VGND VGND VPWR VPWR sky130_fd_sc_hd__fill_1
XFILLER_0_13_225 VGND VGND VPWR VPWR sky130_fd_sc_hd__fill_1
X_1586_ rx_fifo.fifo\[6\]\[2\] net169 net168 rx_fifo.fifo\[1\]\[2\] net165 rx_fifo.fifo\[12\]\[2\]
+ VGND VGND VPWR VPWR _0791_ sky130_fd_sc_hd__a222oi_1
XTAP_475 VGND VPWR sky130_fd_sc_hd__tapvpwrvgnd_1
XTAP_464 VGND VPWR sky130_fd_sc_hd__tapvpwrvgnd_1
XTAP_453 VGND VPWR sky130_fd_sc_hd__tapvpwrvgnd_1
XTAP_442 VGND VPWR sky130_fd_sc_hd__tapvpwrvgnd_1
XTAP_431 VGND VPWR sky130_fd_sc_hd__tapvpwrvgnd_1
XTAP_420 VGND VPWR sky130_fd_sc_hd__tapvpwrvgnd_1
X_1655_ regs.rx_data\[3\] net125 VGND VGND VPWR VPWR _0849_ sky130_fd_sc_hd__nand2_1
XFILLER_0_0_141 VPWR VGND VPWR VGND sky130_ef_sc_hd__decap_12
XTAP_497 VGND VPWR sky130_fd_sc_hd__tapvpwrvgnd_1
XTAP_486 VGND VPWR sky130_fd_sc_hd__tapvpwrvgnd_1
X_2207_ rx_fifo.count\[3\] _1092_ VGND VGND VPWR VPWR _1093_ sky130_fd_sc_hd__nand2_1
X_2138_ _1032_ _1033_ _1034_ VGND VGND VPWR VPWR _1035_ sky130_fd_sc_hd__nand3_1
X_2069_ _0970_ _0976_ _0977_ rx.state\[1\] VGND VGND VPWR VPWR _0978_ sky130_fd_sc_hd__o31ai_1
XFILLER_0_63_169 VGND VGND VPWR VPWR sky130_fd_sc_hd__decap_3
XFILLER_0_39_166 VGND VGND VPWR VPWR sky130_fd_sc_hd__fill_2
XFILLER_0_39_155 VGND VGND VPWR VPWR sky130_fd_sc_hd__fill_2
XFILLER_0_27_306 VGND VGND VPWR VPWR sky130_fd_sc_hd__fill_1
XFILLER_0_42_309 VPWR VGND VPWR VGND sky130_ef_sc_hd__decap_12
XFILLER_0_40_27 VGND VGND VPWR VPWR sky130_fd_sc_hd__fill_1
XFILLER_0_35_383 VGND VGND VPWR VPWR sky130_fd_sc_hd__fill_1
X_1371_ divisor\[3\] _0565_ VGND VGND VPWR VPWR _0610_ sky130_fd_sc_hd__nand2_1
X_1440_ net273 _0658_ _0586_ VGND VGND VPWR VPWR _0662_ sky130_fd_sc_hd__o21ai_0
XFILLER_0_49_69 VGND VGND VPWR VPWR sky130_fd_sc_hd__decap_4
XFILLER_0_10_239 VGND VGND VPWR VPWR sky130_fd_sc_hd__fill_1
XFILLER_0_73_445 VGND VGND VPWR VPWR sky130_fd_sc_hd__decap_3
X_2825_ clknet_leaf_42_clk _0427_ _0001_ VGND VGND VPWR VPWR tx_fifo.fifo\[9\]\[6\]
+ sky130_fd_sc_hd__edfxtp_1
XFILLER_0_69_3 VPWR VGND VPWR VGND sky130_ef_sc_hd__decap_12
X_1707_ net107 net156 VGND VGND VPWR VPWR _0229_ sky130_fd_sc_hd__nor2_1
XFILLER_0_41_342 VGND VGND VPWR VPWR sky130_fd_sc_hd__fill_1
X_2687_ clknet_leaf_28_clk _0254_ net93 VGND VGND VPWR VPWR rx_fifo.fifo\[9\]\[6\]
+ sky130_fd_sc_hd__edfxtp_1
X_1638_ rx.dr _0837_ VGND VGND VPWR VPWR _0838_ sky130_fd_sc_hd__and2_0
XFILLER_0_1_461 VGND VGND VPWR VPWR sky130_fd_sc_hd__fill_2
XFILLER_0_5_288 VGND VGND VPWR VPWR sky130_fd_sc_hd__fill_2
X_2756_ clknet_leaf_40_clk _0470_ net45 VGND VGND VPWR VPWR tx_fifo.fifo\[3\]\[1\]
+ sky130_fd_sc_hd__edfxtp_1
X_1569_ _0770_ _0771_ _0774_ VGND VGND VPWR VPWR _0775_ sky130_fd_sc_hd__nand3_1
XTAP_250 VGND VPWR sky130_fd_sc_hd__tapvpwrvgnd_1
XTAP_261 VGND VPWR sky130_fd_sc_hd__tapvpwrvgnd_1
XTAP_272 VGND VPWR sky130_fd_sc_hd__tapvpwrvgnd_1
XTAP_283 VGND VPWR sky130_fd_sc_hd__tapvpwrvgnd_1
XTAP_294 VGND VPWR sky130_fd_sc_hd__tapvpwrvgnd_1
XFILLER_0_64_445 VGND VGND VPWR VPWR sky130_fd_sc_hd__fill_1
XFILLER_0_51_106 VGND VGND VPWR VPWR sky130_fd_sc_hd__decap_6
Xfanout98 _0021_ VGND VGND VPWR VPWR net98 sky130_fd_sc_hd__buf_4
Xfanout76 _0876_ VGND VGND VPWR VPWR net76 sky130_fd_sc_hd__buf_2
Xfanout54 _1202_ VGND VGND VPWR VPWR net54 sky130_fd_sc_hd__clkbuf_4
Xfanout65 _0885_ VGND VGND VPWR VPWR net65 sky130_fd_sc_hd__clkbuf_2
XFILLER_0_32_375 VGND VGND VPWR VPWR sky130_fd_sc_hd__fill_1
XFILLER_0_74_209 VGND VGND VPWR VPWR sky130_fd_sc_hd__decap_8
XFILLER_0_51_26 VGND VGND VPWR VPWR sky130_fd_sc_hd__fill_1
XFILLER_0_27_169 VGND VGND VPWR VPWR sky130_fd_sc_hd__decap_8
X_2610_ clknet_leaf_19_clk _0309_ net80 VGND VGND VPWR VPWR rx_fifo.fifo\[4\]\[6\]
+ sky130_fd_sc_hd__edfxtp_1
X_2541_ clknet_leaf_18_clk _0229_ net89 VGND VGND VPWR VPWR rx_fifo.fifo\[11\]\[3\]
+ sky130_fd_sc_hd__edfxtp_1
XFILLER_0_50_161 VGND VGND VPWR VPWR sky130_fd_sc_hd__fill_1
XFILLER_0_42_139 VGND VGND VPWR VPWR sky130_fd_sc_hd__fill_1
XFILLER_0_23_320 VPWR VGND VPWR VGND sky130_ef_sc_hd__decap_12
X_2472_ _0901_ net55 VGND VGND VPWR VPWR _0452_ sky130_fd_sc_hd__nor2_1
X_1423_ tx.baud_cnt\[1\] tx.baud_cnt\[0\] net368 VGND VGND VPWR VPWR _0650_ sky130_fd_sc_hd__a21oi_1
X_1354_ divisor\[11\] net214 net160 divisor\[12\] VGND VGND VPWR VPWR _0593_ sky130_fd_sc_hd__o31a_1
XFILLER_0_55_9 VGND VGND VPWR VPWR sky130_fd_sc_hd__decap_4
X_1285_ _0517_ _0526_ VGND VGND VPWR VPWR _0527_ sky130_fd_sc_hd__nor2_1
XFILLER_0_58_283 VGND VGND VPWR VPWR sky130_fd_sc_hd__decap_4
XFILLER_0_46_412 VGND VGND VPWR VPWR sky130_fd_sc_hd__decap_4
X_2808_ clknet_leaf_39_clk _0442_ net39 VGND VGND VPWR VPWR tx_fifo.fifo\[7\]\[5\]
+ sky130_fd_sc_hd__edfxtp_1
XFILLER_0_26_180 VGND VGND VPWR VPWR sky130_fd_sc_hd__decap_6
Xfanout222 regs.rx_fifo_clear VGND VGND VPWR VPWR net222 sky130_fd_sc_hd__buf_2
X_2739_ clknet_leaf_42_clk _0477_ net47 VGND VGND VPWR VPWR tx_fifo.fifo\[2\]\[0\]
+ sky130_fd_sc_hd__edfxtp_1
Xfanout244 net246 VGND VGND VPWR VPWR net244 sky130_fd_sc_hd__clkbuf_4
Xfanout255 net256 VGND VGND VPWR VPWR net255 sky130_fd_sc_hd__clkbuf_4
Xfanout233 rx_fifo.tail\[0\] VGND VGND VPWR VPWR net233 sky130_fd_sc_hd__clkbuf_4
XFILLER_0_64_253 VPWR VGND VPWR VGND sky130_ef_sc_hd__decap_12
XFILLER_0_56_209 VGND VGND VPWR VPWR sky130_fd_sc_hd__fill_2
XFILLER_0_52_404 VGND VGND VPWR VPWR sky130_fd_sc_hd__fill_2
XFILLER_0_24_139 VGND VGND VPWR VPWR sky130_fd_sc_hd__fill_1
XFILLER_0_46_15 VPWR VGND VPWR VGND sky130_ef_sc_hd__decap_12
XFILLER_0_70_201 VGND VGND VPWR VPWR sky130_fd_sc_hd__decap_8
XFILLER_0_43_459 VGND VGND VPWR VPWR sky130_fd_sc_hd__decap_4
XFILLER_0_28_456 VGND VGND VPWR VPWR sky130_fd_sc_hd__fill_2
XFILLER_0_28_445 VGND VGND VPWR VPWR sky130_fd_sc_hd__fill_1
X_1972_ net60 _0907_ VGND VGND VPWR VPWR _0485_ sky130_fd_sc_hd__nor2_1
X_2455_ _1211_ _1216_ _0716_ VGND VGND VPWR VPWR _1217_ sky130_fd_sc_hd__o21ai_1
X_2524_ _1252_ _1254_ _1255_ VGND VGND VPWR VPWR _0155_ sky130_fd_sc_hd__nand3_1
X_1406_ net52 _0641_ VGND VGND VPWR VPWR _0359_ sky130_fd_sc_hd__nor2_1
X_1337_ divisor\[12\] divisor\[11\] net160 VGND VGND VPWR VPWR _0576_ sky130_fd_sc_hd__or3_1
Xhold19 regs.ier\[3\] VGND VGND VPWR VPWR net280 sky130_fd_sc_hd__dlygate4sd3_1
X_1268_ tx_fifo.count\[3\] tx_fifo.count\[2\] tx_fifo.count\[1\] tx_fifo.count\[0\]
+ VGND VGND VPWR VPWR _0513_ sky130_fd_sc_hd__or4_4
X_2386_ _1179_ _1183_ VGND VGND VPWR VPWR _1184_ sky130_fd_sc_hd__nor2_1
XFILLER_0_19_445 VGND VGND VPWR VPWR sky130_fd_sc_hd__decap_3
XFILLER_0_46_253 VGND VGND VPWR VPWR sky130_fd_sc_hd__decap_4
XFILLER_0_6_372 VGND VGND VPWR VPWR sky130_fd_sc_hd__decap_6
XFILLER_0_14_183 VPWR VGND VPWR VGND sky130_ef_sc_hd__decap_12
XFILLER_0_52_201 VPWR VGND VPWR VGND sky130_ef_sc_hd__decap_12
XFILLER_0_4_309 VGND VGND VPWR VPWR sky130_fd_sc_hd__decap_8
XFILLER_0_57_14 VGND VGND VPWR VPWR sky130_fd_sc_hd__decap_3
Xmax_cap208 net209 VGND VGND VPWR VPWR net208 sky130_fd_sc_hd__clkbuf_2
X_2171_ tx_fifo.fifo\[13\]\[1\] _0999_ net188 tx_fifo.fifo\[4\]\[1\] _1064_ VGND VGND
+ VPWR VPWR _1065_ sky130_fd_sc_hd__a221oi_2
X_2240_ parity_en _1116_ VGND VGND VPWR VPWR _1122_ sky130_fd_sc_hd__nand2_1
XFILLER_0_73_57 VPWR VGND VPWR VGND sky130_ef_sc_hd__decap_12
XFILLER_0_43_212 VPWR VGND VPWR VGND sky130_ef_sc_hd__decap_12
XFILLER_0_28_253 VGND VGND VPWR VPWR sky130_fd_sc_hd__decap_3
XFILLER_0_3_353 VGND VGND VPWR VPWR sky130_fd_sc_hd__fill_2
XFILLER_0_7_169 VGND VGND VPWR VPWR sky130_fd_sc_hd__decap_3
X_1886_ net68 _0895_ VGND VGND VPWR VPWR _0409_ sky130_fd_sc_hd__nor2_1
X_1955_ net62 _0905_ VGND VGND VPWR VPWR _0470_ sky130_fd_sc_hd__nor2_1
XFILLER_0_51_3 VGND VGND VPWR VPWR sky130_fd_sc_hd__decap_8
X_2507_ tx_fifo.count\[4\] _0923_ VGND VGND VPWR VPWR _1245_ sky130_fd_sc_hd__xor2_1
XFILLER_0_11_164 VGND VGND VPWR VPWR sky130_fd_sc_hd__decap_4
X_2438_ _0893_ net54 VGND VGND VPWR VPWR _0404_ sky130_fd_sc_hd__nor2_1
X_2369_ tx.state\[1\] _1113_ _1116_ _1167_ VGND VGND VPWR VPWR _1168_ sky130_fd_sc_hd__a22oi_1
XPHY_148 VGND VGND VPWR VPWR sky130_fd_sc_hd__decap_3
XPHY_137 VGND VGND VPWR VPWR sky130_fd_sc_hd__decap_3
XFILLER_0_63_90 VGND VGND VPWR VPWR sky130_fd_sc_hd__fill_2
XPHY_126 VGND VGND VPWR VPWR sky130_fd_sc_hd__decap_3
XPHY_115 VGND VGND VPWR VPWR sky130_fd_sc_hd__decap_3
XPHY_104 VGND VGND VPWR VPWR sky130_fd_sc_hd__decap_3
XFILLER_0_69_120 VPWR VGND VPWR VGND sky130_ef_sc_hd__decap_12
XFILLER_0_57_337 VPWR VGND VPWR VGND sky130_ef_sc_hd__decap_12
XFILLER_0_43_27 VGND VGND VPWR VPWR sky130_fd_sc_hd__decap_8
Xmax_cap84 _0027_ VGND VGND VPWR VPWR net84 sky130_fd_sc_hd__buf_1
Xmax_cap51 _0015_ VGND VGND VPWR VPWR net51 sky130_fd_sc_hd__clkbuf_2
XPHY_6 VGND VGND VPWR VPWR sky130_fd_sc_hd__decap_3
Xmax_cap40 _0004_ VGND VGND VPWR VPWR net40 sky130_fd_sc_hd__buf_2
X_1671_ net108 net159 VGND VGND VPWR VPWR _0196_ sky130_fd_sc_hd__nor2_1
X_1740_ net108 net153 VGND VGND VPWR VPWR _0262_ sky130_fd_sc_hd__nor2_1
XFILLER_0_25_212 VPWR VGND VPWR VGND sky130_ef_sc_hd__decap_12
XFILLER_0_68_57 VGND VGND VPWR VPWR sky130_fd_sc_hd__decap_3
XTAP_668 VGND VPWR sky130_fd_sc_hd__tapvpwrvgnd_1
XTAP_657 VGND VPWR sky130_fd_sc_hd__tapvpwrvgnd_1
XTAP_646 VGND VPWR sky130_fd_sc_hd__tapvpwrvgnd_1
XTAP_635 VGND VPWR sky130_fd_sc_hd__tapvpwrvgnd_1
XTAP_624 VGND VPWR sky130_fd_sc_hd__tapvpwrvgnd_1
XTAP_613 VGND VPWR sky130_fd_sc_hd__tapvpwrvgnd_1
XTAP_602 VGND VPWR sky130_fd_sc_hd__tapvpwrvgnd_1
XFILLER_0_0_389 VGND VGND VPWR VPWR sky130_fd_sc_hd__decap_3
XTAP_679 VGND VPWR sky130_fd_sc_hd__tapvpwrvgnd_1
X_2154_ tx_fifo.fifo\[5\]\[2\] net388 VGND VGND VPWR VPWR _1049_ sky130_fd_sc_hd__nand2_1
X_2223_ _1091_ _1105_ _1106_ VGND VGND VPWR VPWR _1107_ sky130_fd_sc_hd__o21ai_0
X_2085_ rx.shift_reg\[3\] net297 _0987_ VGND VGND VPWR VPWR _0056_ sky130_fd_sc_hd__mux2_1
X_2987_ clknet_leaf_12_clk _0369_ net250 VGND VGND VPWR VPWR tx.baud_cnt\[6\] sky130_fd_sc_hd__dfrtp_1
XFILLER_0_48_315 VGND VGND VPWR VPWR sky130_fd_sc_hd__decap_6
XFILLER_0_33_93 VPWR VGND VPWR VGND sky130_ef_sc_hd__decap_12
XFILLER_0_8_445 VPWR VGND VPWR VGND sky130_ef_sc_hd__decap_12
X_1938_ net63 _0902_ VGND VGND VPWR VPWR _0454_ sky130_fd_sc_hd__nor2_1
XFILLER_0_31_237 VGND VGND VPWR VPWR sky130_fd_sc_hd__decap_6
X_1869_ net66 _0891_ VGND VGND VPWR VPWR _0392_ sky130_fd_sc_hd__nor2_1
XFILLER_0_16_245 VGND VGND VPWR VPWR sky130_fd_sc_hd__decap_6
XFILLER_0_39_337 VGND VGND VPWR VPWR sky130_fd_sc_hd__fill_2
XFILLER_0_38_27 VGND VGND VPWR VPWR sky130_fd_sc_hd__fill_1
XFILLER_0_54_15 VGND VGND VPWR VPWR sky130_fd_sc_hd__decap_8
X_2841_ clknet_leaf_6_clk _0144_ net247 VGND VGND VPWR VPWR regs.ier\[3\] sky130_fd_sc_hd__dfrtp_1
X_2910_ clknet_leaf_34_clk net302 net256 VGND VGND VPWR VPWR tx.shift_reg\[1\] sky130_fd_sc_hd__dfrtp_1
X_1654_ _0841_ net109 VGND VGND VPWR VPWR _0186_ sky130_fd_sc_hd__nor2_1
X_1723_ net119 net154 VGND VGND VPWR VPWR _0257_ sky130_fd_sc_hd__nor2_1
Xhold105 rx.sample_cnt\[3\] VGND VGND VPWR VPWR net366 sky130_fd_sc_hd__dlygate4sd3_1
X_2772_ clknet_leaf_39_clk _0374_ net43 VGND VGND VPWR VPWR tx_fifo.fifo\[15\]\[1\]
+ sky130_fd_sc_hd__edfxtp_1
Xhold116 rx.shift_reg\[3\] VGND VGND VPWR VPWR net377 sky130_fd_sc_hd__dlygate4sd3_1
X_1585_ rx_fifo.fifo\[3\]\[2\] net176 net171 rx_fifo.fifo\[11\]\[2\] net166 rx_fifo.fifo\[2\]\[2\]
+ VGND VGND VPWR VPWR _0790_ sky130_fd_sc_hd__a222oi_1
XTAP_498 VGND VPWR sky130_fd_sc_hd__tapvpwrvgnd_1
XTAP_487 VGND VPWR sky130_fd_sc_hd__tapvpwrvgnd_1
XTAP_476 VGND VPWR sky130_fd_sc_hd__tapvpwrvgnd_1
XTAP_465 VGND VPWR sky130_fd_sc_hd__tapvpwrvgnd_1
XTAP_454 VGND VPWR sky130_fd_sc_hd__tapvpwrvgnd_1
XTAP_443 VGND VPWR sky130_fd_sc_hd__tapvpwrvgnd_1
XTAP_432 VGND VPWR sky130_fd_sc_hd__tapvpwrvgnd_1
XTAP_421 VGND VPWR sky130_fd_sc_hd__tapvpwrvgnd_1
XTAP_410 VGND VPWR sky130_fd_sc_hd__tapvpwrvgnd_1
X_2206_ _1090_ _1091_ VGND VGND VPWR VPWR _1092_ sky130_fd_sc_hd__nor2_1
XFILLER_0_21_281 VGND VGND VPWR VPWR sky130_fd_sc_hd__fill_2
XFILLER_0_0_153 VPWR VGND VPWR VGND sky130_ef_sc_hd__decap_12
XFILLER_0_0_197 VGND VGND VPWR VPWR sky130_fd_sc_hd__decap_8
XFILLER_0_76_421 VPWR VGND VPWR VGND sky130_ef_sc_hd__decap_12
X_2137_ tx_fifo.fifo\[9\]\[4\] net192 net186 tx_fifo.fifo\[6\]\[4\] tx_fifo.fifo\[2\]\[4\]
+ net184 VGND VGND VPWR VPWR _1034_ sky130_fd_sc_hd__a222oi_1
X_2068_ _0945_ _0950_ _0964_ VGND VGND VPWR VPWR _0977_ sky130_fd_sc_hd__or3_1
XFILLER_0_8_231 VGND VGND VPWR VPWR sky130_fd_sc_hd__decap_3
XFILLER_0_8_242 VGND VGND VPWR VPWR sky130_fd_sc_hd__decap_3
XFILLER_0_8_81 VGND VGND VPWR VPWR sky130_fd_sc_hd__decap_3
XFILLER_0_12_292 VGND VGND VPWR VPWR sky130_fd_sc_hd__decap_6
XFILLER_0_24_29 VGND VGND VPWR VPWR sky130_fd_sc_hd__decap_8
XFILLER_0_50_365 VPWR VGND VPWR VGND sky130_ef_sc_hd__decap_12
XFILLER_0_49_37 VGND VGND VPWR VPWR sky130_fd_sc_hd__fill_1
X_1370_ _0604_ _0606_ _0607_ _0608_ VGND VGND VPWR VPWR _0609_ sky130_fd_sc_hd__nor4bb_1
XFILLER_0_58_421 VPWR VGND VPWR VGND sky130_ef_sc_hd__decap_12
XFILLER_0_45_159 VGND VGND VPWR VPWR sky130_fd_sc_hd__decap_8
XFILLER_0_26_340 VGND VGND VPWR VPWR sky130_fd_sc_hd__fill_1
XFILLER_0_5_223 VGND VGND VPWR VPWR sky130_fd_sc_hd__fill_1
X_2824_ clknet_leaf_41_clk _0426_ net37 VGND VGND VPWR VPWR tx_fifo.fifo\[9\]\[5\]
+ sky130_fd_sc_hd__edfxtp_1
XFILLER_0_18_307 VGND VGND VPWR VPWR sky130_fd_sc_hd__fill_1
XFILLER_0_18_318 VPWR VGND VPWR VGND sky130_ef_sc_hd__decap_12
X_1706_ net109 net156 VGND VGND VPWR VPWR _0230_ sky130_fd_sc_hd__nor2_1
X_1637_ rx_fifo.count\[4\] net216 VGND VGND VPWR VPWR _0837_ sky130_fd_sc_hd__nand2_1
X_2686_ clknet_leaf_27_clk _0253_ net93 VGND VGND VPWR VPWR rx_fifo.fifo\[9\]\[5\]
+ sky130_fd_sc_hd__edfxtp_1
XFILLER_0_30_72 VGND VGND VPWR VPWR sky130_fd_sc_hd__decap_6
X_2755_ clknet_leaf_42_clk _0469_ _0009_ VGND VGND VPWR VPWR tx_fifo.fifo\[3\]\[0\]
+ sky130_fd_sc_hd__edfxtp_1
X_1499_ rx.baud_cnt\[0\] rx.baud_cnt\[1\] net365 VGND VGND VPWR VPWR _0711_ sky130_fd_sc_hd__a21oi_1
X_1568_ rx_fifo.fifo\[10\]\[3\] _0532_ net161 rx_fifo.fifo\[9\]\[3\] _0773_ VGND VGND
+ VPWR VPWR _0774_ sky130_fd_sc_hd__a221oi_2
XTAP_240 VGND VPWR sky130_fd_sc_hd__tapvpwrvgnd_1
XTAP_251 VGND VPWR sky130_fd_sc_hd__tapvpwrvgnd_1
XTAP_262 VGND VPWR sky130_fd_sc_hd__tapvpwrvgnd_1
XTAP_273 VGND VPWR sky130_fd_sc_hd__tapvpwrvgnd_1
XTAP_284 VGND VPWR sky130_fd_sc_hd__tapvpwrvgnd_1
XTAP_295 VGND VPWR sky130_fd_sc_hd__tapvpwrvgnd_1
Xfanout55 _1202_ VGND VGND VPWR VPWR net55 sky130_fd_sc_hd__clkbuf_2
Xfanout99 _0022_ VGND VGND VPWR VPWR net99 sky130_fd_sc_hd__buf_4
Xfanout88 _0029_ VGND VGND VPWR VPWR net88 sky130_fd_sc_hd__buf_4
Xfanout66 _0884_ VGND VGND VPWR VPWR net66 sky130_fd_sc_hd__clkbuf_4
Xfanout77 _0700_ VGND VGND VPWR VPWR net77 sky130_fd_sc_hd__buf_2
XFILLER_0_3_3 VGND VGND VPWR VPWR sky130_fd_sc_hd__decap_4
XFILLER_0_59_229 VGND VGND VPWR VPWR sky130_fd_sc_hd__fill_1
XFILLER_0_59_207 VPWR VGND VPWR VGND sky130_ef_sc_hd__decap_12
XFILLER_0_70_405 VGND VGND VPWR VPWR sky130_fd_sc_hd__fill_1
X_1422_ net53 _0649_ VGND VGND VPWR VPWR _0366_ sky130_fd_sc_hd__nor2_1
X_2540_ clknet_leaf_22_clk _0228_ net89 VGND VGND VPWR VPWR rx_fifo.fifo\[11\]\[2\]
+ sky130_fd_sc_hd__edfxtp_1
XFILLER_0_35_181 VPWR VGND VPWR VGND sky130_ef_sc_hd__decap_12
XFILLER_0_23_332 VGND VGND VPWR VPWR sky130_fd_sc_hd__decap_4
X_2471_ net77 _0941_ _1154_ _1225_ _1224_ VGND VGND VPWR VPWR _0141_ sky130_fd_sc_hd__o41ai_1
X_1353_ tx.baud_cnt\[7\] _0591_ VGND VGND VPWR VPWR _0592_ sky130_fd_sc_hd__xnor2_1
X_1284_ net234 rx_fifo.head\[3\] VGND VGND VPWR VPWR _0526_ sky130_fd_sc_hd__nand2b_1
XFILLER_0_73_265 VGND VGND VPWR VPWR sky130_fd_sc_hd__decap_6
XFILLER_0_61_438 VGND VGND VPWR VPWR sky130_fd_sc_hd__decap_8
XFILLER_0_61_405 VPWR VGND VPWR VGND sky130_ef_sc_hd__decap_12
X_2807_ clknet_leaf_4_clk _0441_ net39 VGND VGND VPWR VPWR tx_fifo.fifo\[7\]\[4\]
+ sky130_fd_sc_hd__edfxtp_1
X_2738_ clknet_leaf_2_clk _0492_ _0012_ VGND VGND VPWR VPWR tx_fifo.fifo\[1\]\[7\]
+ sky130_fd_sc_hd__edfxtp_1
XFILLER_0_14_321 VGND VGND VPWR VPWR sky130_fd_sc_hd__decap_6
XFILLER_0_14_365 VGND VGND VPWR VPWR sky130_fd_sc_hd__fill_2
Xfanout245 net246 VGND VGND VPWR VPWR net245 sky130_fd_sc_hd__clkbuf_4
X_2669_ clknet_leaf_16_clk _0270_ net96 VGND VGND VPWR VPWR rx_fifo.fifo\[7\]\[10\]
+ sky130_fd_sc_hd__edfxtp_1
Xfanout234 rx_fifo.head\[2\] VGND VGND VPWR VPWR net234 sky130_fd_sc_hd__clkbuf_4
Xfanout223 tx_fifo.tail\[0\] VGND VGND VPWR VPWR net223 sky130_fd_sc_hd__clkbuf_8
Xfanout256 net261 VGND VGND VPWR VPWR net256 sky130_fd_sc_hd__clkbuf_4
XFILLER_0_1_281 VGND VGND VPWR VPWR sky130_fd_sc_hd__decap_6
XFILLER_0_14_376 VGND VGND VPWR VPWR sky130_fd_sc_hd__fill_2
XFILLER_0_64_265 VGND VGND VPWR VPWR sky130_fd_sc_hd__decap_3
XFILLER_0_64_243 VGND VGND VPWR VPWR sky130_fd_sc_hd__fill_2
XFILLER_0_17_181 VPWR VGND VPWR VGND sky130_ef_sc_hd__decap_12
XFILLER_0_20_302 VGND VGND VPWR VPWR sky130_fd_sc_hd__fill_1
XFILLER_0_46_27 VGND VGND VPWR VPWR sky130_fd_sc_hd__fill_1
XFILLER_0_62_59 VPWR VGND VPWR VGND sky130_ef_sc_hd__decap_12
XFILLER_0_62_26 VGND VGND VPWR VPWR sky130_fd_sc_hd__fill_2
XFILLER_0_62_15 VGND VGND VPWR VPWR sky130_fd_sc_hd__decap_6
XFILLER_0_28_424 VGND VGND VPWR VPWR sky130_fd_sc_hd__fill_1
XFILLER_0_55_287 VPWR VGND VPWR VGND sky130_ef_sc_hd__decap_12
XFILLER_0_43_438 VGND VGND VPWR VPWR sky130_fd_sc_hd__fill_2
XFILLER_0_23_140 VGND VGND VPWR VPWR sky130_fd_sc_hd__fill_2
X_1971_ net62 _0907_ VGND VGND VPWR VPWR _0486_ sky130_fd_sc_hd__nor2_1
XFILLER_0_11_52 VGND VGND VPWR VPWR sky130_fd_sc_hd__fill_1
X_1405_ tx.baud_cnt\[11\] _0635_ VGND VGND VPWR VPWR _0641_ sky130_fd_sc_hd__xnor2_1
X_2454_ _1212_ _1213_ _1214_ _1215_ VGND VGND VPWR VPWR _1216_ sky130_fd_sc_hd__nand4_1
XFILLER_0_11_335 VGND VGND VPWR VPWR sky130_fd_sc_hd__fill_1
X_2523_ tx.state\[1\] net307 _1113_ _1253_ _0991_ VGND VGND VPWR VPWR _1255_ sky130_fd_sc_hd__a32oi_1
X_2385_ _1175_ _1180_ _1181_ _1182_ VGND VGND VPWR VPWR _1183_ sky130_fd_sc_hd__nand4_1
Xinput1 addr[0] VGND VGND VPWR VPWR net1 sky130_fd_sc_hd__buf_2
X_1336_ divisor\[11\] net160 VGND VGND VPWR VPWR _0575_ sky130_fd_sc_hd__nor2_1
XFILLER_0_36_82 VGND VGND VPWR VPWR sky130_fd_sc_hd__fill_2
X_1267_ tx_fifo.count\[3\] tx_fifo.count\[2\] tx_fifo.count\[1\] tx_fifo.count\[0\]
+ VGND VGND VPWR VPWR _0512_ sky130_fd_sc_hd__nor4_1
XFILLER_0_34_405 VGND VGND VPWR VPWR sky130_fd_sc_hd__decap_6
XFILLER_0_61_268 VGND VGND VPWR VPWR sky130_fd_sc_hd__decap_8
XFILLER_0_6_395 VPWR VGND VPWR VGND sky130_ef_sc_hd__decap_12
XFILLER_0_14_195 VGND VGND VPWR VPWR sky130_fd_sc_hd__fill_1
XFILLER_0_32_29 VPWR VGND VPWR VGND sky130_ef_sc_hd__decap_12
Xclkbuf_leaf_39_clk clknet_2_0__leaf_clk VGND VGND VPWR VPWR clknet_leaf_39_clk sky130_fd_sc_hd__clkbuf_16
XFILLER_0_16_19 VGND VGND VPWR VPWR sky130_fd_sc_hd__fill_1
XFILLER_0_77_390 VGND VGND VPWR VPWR sky130_fd_sc_hd__fill_2
XFILLER_0_52_213 VGND VGND VPWR VPWR sky130_fd_sc_hd__fill_1
XFILLER_0_37_221 VGND VGND VPWR VPWR sky130_fd_sc_hd__decap_3
XFILLER_0_57_37 VGND VGND VPWR VPWR sky130_fd_sc_hd__decap_4
Xmax_cap209 _0888_ VGND VGND VPWR VPWR net209 sky130_fd_sc_hd__clkbuf_2
XFILLER_0_20_132 VGND VGND VPWR VPWR sky130_fd_sc_hd__decap_8
XFILLER_0_73_69 VGND VGND VPWR VPWR sky130_fd_sc_hd__fill_1
X_2170_ tx_fifo.fifo\[1\]\[1\] net189 net184 tx_fifo.fifo\[2\]\[1\] VGND VGND VPWR
+ VPWR _1064_ sky130_fd_sc_hd__a22o_1
XFILLER_0_28_221 VGND VGND VPWR VPWR sky130_fd_sc_hd__fill_1
XFILLER_0_28_210 VGND VGND VPWR VPWR sky130_fd_sc_hd__fill_1
X_1954_ net65 _0905_ VGND VGND VPWR VPWR _0471_ sky130_fd_sc_hd__nor2_1
XFILLER_0_43_279 VGND VGND VPWR VPWR sky130_fd_sc_hd__fill_1
X_1885_ net70 _0895_ VGND VGND VPWR VPWR _0410_ sky130_fd_sc_hd__nor2_1
XFILLER_0_11_121 VPWR VGND VPWR VGND sky130_ef_sc_hd__decap_12
XFILLER_0_16_427 VGND VGND VPWR VPWR sky130_fd_sc_hd__decap_6
XFILLER_0_44_3 VPWR VGND VPWR VGND sky130_ef_sc_hd__decap_12
X_2506_ tx_fifo.count\[4\] _0926_ _0919_ VGND VGND VPWR VPWR _1244_ sky130_fd_sc_hd__a21oi_1
X_2437_ _0891_ net54 VGND VGND VPWR VPWR _0396_ sky130_fd_sc_hd__nor2_1
X_2368_ parity_en _0990_ VGND VGND VPWR VPWR _1167_ sky130_fd_sc_hd__nor2_1
X_2299_ net7 net362 _1135_ VGND VGND VPWR VPWR _0121_ sky130_fd_sc_hd__mux2_1
XPHY_116 VGND VGND VPWR VPWR sky130_fd_sc_hd__decap_3
XPHY_105 VGND VGND VPWR VPWR sky130_fd_sc_hd__decap_3
X_1319_ rx_fifo.fifo\[0\]\[8\] net215 net164 rx_fifo.fifo\[15\]\[8\] _0558_ VGND VGND
+ VPWR VPWR _0559_ sky130_fd_sc_hd__a221oi_2
XPHY_149 VGND VGND VPWR VPWR sky130_fd_sc_hd__decap_3
XFILLER_0_74_393 VGND VGND VPWR VPWR sky130_fd_sc_hd__fill_1
XPHY_138 VGND VGND VPWR VPWR sky130_fd_sc_hd__decap_3
XPHY_127 VGND VGND VPWR VPWR sky130_fd_sc_hd__decap_3
XFILLER_0_19_276 VGND VGND VPWR VPWR sky130_fd_sc_hd__fill_1
XFILLER_0_69_198 VGND VGND VPWR VPWR sky130_fd_sc_hd__fill_2
XFILLER_0_69_132 VGND VGND VPWR VPWR sky130_fd_sc_hd__fill_2
XFILLER_0_57_349 VGND VGND VPWR VPWR sky130_fd_sc_hd__decap_8
XPHY_7 VGND VGND VPWR VPWR sky130_fd_sc_hd__decap_3
Xmax_cap41 _0005_ VGND VGND VPWR VPWR net41 sky130_fd_sc_hd__clkbuf_2
XFILLER_0_65_393 VGND VGND VPWR VPWR sky130_fd_sc_hd__fill_1
X_1670_ net109 net159 VGND VGND VPWR VPWR _0197_ sky130_fd_sc_hd__nor2_1
XFILLER_0_40_205 VGND VGND VPWR VPWR sky130_fd_sc_hd__fill_2
XFILLER_0_25_279 VGND VGND VPWR VPWR sky130_fd_sc_hd__fill_1
XTAP_669 VGND VPWR sky130_fd_sc_hd__tapvpwrvgnd_1
XTAP_658 VGND VPWR sky130_fd_sc_hd__tapvpwrvgnd_1
XTAP_647 VGND VPWR sky130_fd_sc_hd__tapvpwrvgnd_1
XTAP_636 VGND VPWR sky130_fd_sc_hd__tapvpwrvgnd_1
XTAP_625 VGND VPWR sky130_fd_sc_hd__tapvpwrvgnd_1
XTAP_614 VGND VPWR sky130_fd_sc_hd__tapvpwrvgnd_1
XTAP_603 VGND VPWR sky130_fd_sc_hd__tapvpwrvgnd_1
X_2222_ net126 _1084_ _1105_ VGND VGND VPWR VPWR _1106_ sky130_fd_sc_hd__o21ai_0
X_2084_ rx.shift_reg\[4\] net290 _0987_ VGND VGND VPWR VPWR _0055_ sky130_fd_sc_hd__mux2_1
X_2153_ net296 _0991_ _0992_ net275 _1048_ VGND VGND VPWR VPWR _0063_ sky130_fd_sc_hd__a221o_1
XFILLER_0_17_51 VGND VGND VPWR VPWR sky130_fd_sc_hd__decap_4
X_2986_ clknet_leaf_12_clk _0368_ net250 VGND VGND VPWR VPWR tx.baud_cnt\[5\] sky130_fd_sc_hd__dfrtp_2
XFILLER_0_56_382 VGND VGND VPWR VPWR sky130_fd_sc_hd__fill_1
X_1937_ net64 _0902_ VGND VGND VPWR VPWR _0455_ sky130_fd_sc_hd__nor2_1
XFILLER_0_8_457 VGND VGND VPWR VPWR sky130_fd_sc_hd__decap_6
X_1799_ net103 _0870_ VGND VGND VPWR VPWR _0315_ sky130_fd_sc_hd__nor2_1
X_1868_ net68 _0891_ VGND VGND VPWR VPWR _0393_ sky130_fd_sc_hd__nor2_1
XFILLER_0_58_80 VGND VGND VPWR VPWR sky130_fd_sc_hd__decap_4
XFILLER_0_57_102 VGND VGND VPWR VPWR sky130_fd_sc_hd__decap_4
XFILLER_0_70_37 VGND VGND VPWR VPWR sky130_fd_sc_hd__decap_3
XFILLER_0_70_15 VPWR VGND VPWR VGND sky130_ef_sc_hd__decap_12
XFILLER_0_57_113 VPWR VGND VPWR VGND sky130_ef_sc_hd__decap_12
X_2840_ clknet_leaf_15_clk _0122_ net248 VGND VGND VPWR VPWR regs.ier\[2\] sky130_fd_sc_hd__dfrtp_1
XFILLER_0_5_405 VPWR VGND VPWR VGND sky130_ef_sc_hd__decap_12
X_2771_ clknet_leaf_1_clk _0373_ net43 VGND VGND VPWR VPWR tx_fifo.fifo\[15\]\[0\]
+ sky130_fd_sc_hd__edfxtp_1
Xhold117 rx.baud_cnt\[5\] VGND VGND VPWR VPWR net378 sky130_fd_sc_hd__dlygate4sd3_1
X_1584_ rx_fifo.fifo\[0\]\[2\] net215 net170 rx_fifo.fifo\[14\]\[2\] rx_fifo.fifo\[5\]\[2\]
+ net163 VGND VGND VPWR VPWR _0789_ sky130_fd_sc_hd__a222oi_1
Xhold106 net22 VGND VGND VPWR VPWR net367 sky130_fd_sc_hd__dlygate4sd3_1
X_1722_ _0855_ _0859_ VGND VGND VPWR VPWR _0862_ sky130_fd_sc_hd__nand2_1
XTAP_400 VGND VPWR sky130_fd_sc_hd__tapvpwrvgnd_1
X_1653_ regs.rx_data\[4\] net125 VGND VGND VPWR VPWR _0848_ sky130_fd_sc_hd__nand2_1
XFILLER_0_5_449 VGND VGND VPWR VPWR sky130_fd_sc_hd__decap_8
XTAP_499 VGND VPWR sky130_fd_sc_hd__tapvpwrvgnd_1
XTAP_488 VGND VPWR sky130_fd_sc_hd__tapvpwrvgnd_1
XTAP_477 VGND VPWR sky130_fd_sc_hd__tapvpwrvgnd_1
XTAP_466 VGND VPWR sky130_fd_sc_hd__tapvpwrvgnd_1
XTAP_455 VGND VPWR sky130_fd_sc_hd__tapvpwrvgnd_1
XTAP_444 VGND VPWR sky130_fd_sc_hd__tapvpwrvgnd_1
XTAP_433 VGND VPWR sky130_fd_sc_hd__tapvpwrvgnd_1
XTAP_422 VGND VPWR sky130_fd_sc_hd__tapvpwrvgnd_1
X_2205_ regs.rx_fifo_pop net17 net124 VGND VGND VPWR VPWR _1091_ sky130_fd_sc_hd__a21oi_2
XTAP_411 VGND VPWR sky130_fd_sc_hd__tapvpwrvgnd_1
XFILLER_0_28_83 VGND VGND VPWR VPWR sky130_fd_sc_hd__fill_1
XFILLER_0_21_293 VGND VGND VPWR VPWR sky130_fd_sc_hd__fill_1
XFILLER_0_0_165 VGND VGND VPWR VPWR sky130_fd_sc_hd__decap_3
XFILLER_0_76_433 VPWR VGND VPWR VGND sky130_ef_sc_hd__decap_12
XFILLER_0_48_135 VGND VGND VPWR VPWR sky130_fd_sc_hd__decap_4
X_2136_ tx_fifo.fifo\[10\]\[4\] net195 _1005_ tx_fifo.fifo\[11\]\[4\] net193 tx_fifo.fifo\[3\]\[4\]
+ VGND VGND VPWR VPWR _1033_ sky130_fd_sc_hd__a222oi_1
X_2067_ _0944_ _0975_ _0973_ _0951_ VGND VGND VPWR VPWR _0976_ sky130_fd_sc_hd__o211ai_2
X_2969_ clknet_leaf_10_clk _0171_ net244 VGND VGND VPWR VPWR rx.baud_cnt\[4\] sky130_fd_sc_hd__dfrtp_1
XFILLER_0_60_70 VGND VGND VPWR VPWR sky130_fd_sc_hd__fill_2
XFILLER_0_56_190 VGND VGND VPWR VPWR sky130_fd_sc_hd__decap_6
XFILLER_0_8_93 VGND VGND VPWR VPWR sky130_fd_sc_hd__fill_2
XFILLER_0_39_113 VGND VGND VPWR VPWR sky130_fd_sc_hd__decap_8
XFILLER_0_40_29 VPWR VGND VPWR VGND sky130_ef_sc_hd__decap_12
XFILLER_0_50_377 VPWR VGND VPWR VGND sky130_ef_sc_hd__decap_12
XFILLER_0_50_300 VGND VGND VPWR VPWR sky130_fd_sc_hd__decap_8
XFILLER_0_2_419 VGND VGND VPWR VPWR sky130_fd_sc_hd__fill_1
XFILLER_0_4_29 VGND VGND VPWR VPWR sky130_fd_sc_hd__decap_4
XFILLER_0_58_433 VGND VGND VPWR VPWR sky130_fd_sc_hd__decap_6
XFILLER_0_14_41 VGND VGND VPWR VPWR sky130_fd_sc_hd__decap_6
X_1705_ net111 net156 VGND VGND VPWR VPWR _0231_ sky130_fd_sc_hd__nor2_1
X_2823_ clknet_leaf_43_clk _0425_ _0001_ VGND VGND VPWR VPWR tx_fifo.fifo\[9\]\[4\]
+ sky130_fd_sc_hd__edfxtp_1
XFILLER_0_14_85 VPWR VGND VPWR VGND sky130_ef_sc_hd__decap_12
X_2754_ clknet_leaf_0_clk _0404_ _0010_ VGND VGND VPWR VPWR tx_fifo.fifo\[12\]\[7\]
+ sky130_fd_sc_hd__edfxtp_1
X_1636_ net4 _0836_ VGND VGND VPWR VPWR net24 sky130_fd_sc_hd__and2_0
X_1567_ _0768_ _0769_ net131 VGND VGND VPWR VPWR _0773_ sky130_fd_sc_hd__nand3_1
X_2685_ clknet_leaf_28_clk _0252_ net93 VGND VGND VPWR VPWR rx_fifo.fifo\[9\]\[4\]
+ sky130_fd_sc_hd__edfxtp_1
XFILLER_0_1_441 VGND VGND VPWR VPWR sky130_fd_sc_hd__decap_6
XTAP_230 VGND VPWR sky130_fd_sc_hd__tapvpwrvgnd_1
XTAP_241 VGND VPWR sky130_fd_sc_hd__tapvpwrvgnd_1
X_1498_ net74 _0710_ VGND VGND VPWR VPWR _0170_ sky130_fd_sc_hd__nor2_1
XFILLER_0_55_70 VPWR VGND VPWR VGND sky130_ef_sc_hd__decap_12
X_2119_ _1013_ _1016_ _1017_ _1007_ VGND VGND VPWR VPWR _1018_ sky130_fd_sc_hd__and4b_1
XTAP_252 VGND VPWR sky130_fd_sc_hd__tapvpwrvgnd_1
XTAP_263 VGND VPWR sky130_fd_sc_hd__tapvpwrvgnd_1
XTAP_274 VGND VPWR sky130_fd_sc_hd__tapvpwrvgnd_1
XTAP_285 VGND VPWR sky130_fd_sc_hd__tapvpwrvgnd_1
XTAP_296 VGND VPWR sky130_fd_sc_hd__tapvpwrvgnd_1
XFILLER_0_71_91 VGND VGND VPWR VPWR sky130_fd_sc_hd__decap_6
XFILLER_0_64_403 VPWR VGND VPWR VGND sky130_ef_sc_hd__decap_12
XFILLER_0_49_422 VGND VGND VPWR VPWR sky130_fd_sc_hd__fill_2
Xfanout89 _0030_ VGND VGND VPWR VPWR net89 sky130_fd_sc_hd__buf_4
Xfanout67 _0884_ VGND VGND VPWR VPWR net67 sky130_fd_sc_hd__clkbuf_2
XFILLER_0_29_190 VPWR VGND VPWR VGND sky130_ef_sc_hd__decap_12
XFILLER_0_17_330 VGND VGND VPWR VPWR sky130_fd_sc_hd__decap_6
XFILLER_0_59_219 VGND VGND VPWR VPWR sky130_fd_sc_hd__decap_4
XFILLER_0_42_108 VGND VGND VPWR VPWR sky130_fd_sc_hd__decap_4
XFILLER_0_27_105 VGND VGND VPWR VPWR sky130_fd_sc_hd__decap_3
X_1421_ tx.baud_cnt\[3\] _0630_ VGND VGND VPWR VPWR _0649_ sky130_fd_sc_hd__xnor2_1
XFILLER_0_50_141 VGND VGND VPWR VPWR sky130_fd_sc_hd__decap_8
XFILLER_0_35_193 VPWR VGND VPWR VGND sky130_ef_sc_hd__decap_12
XFILLER_0_2_238 VGND VGND VPWR VPWR sky130_fd_sc_hd__decap_8
X_2470_ _0940_ _1153_ rx.sample_cnt\[3\] VGND VGND VPWR VPWR _1225_ sky130_fd_sc_hd__a21oi_1
X_1352_ divisor\[7\] _0590_ _0572_ VGND VGND VPWR VPWR _0591_ sky130_fd_sc_hd__a21oi_1
X_1283_ _0517_ _0523_ VGND VGND VPWR VPWR _0525_ sky130_fd_sc_hd__nor2_1
XFILLER_0_18_149 VGND VGND VPWR VPWR sky130_fd_sc_hd__fill_1
XFILLER_0_61_417 VPWR VGND VPWR VGND sky130_ef_sc_hd__decap_12
X_2668_ clknet_leaf_15_clk _0279_ net96 VGND VGND VPWR VPWR rx_fifo.fifo\[7\]\[9\]
+ sky130_fd_sc_hd__edfxtp_1
XFILLER_0_41_130 VGND VGND VPWR VPWR sky130_fd_sc_hd__decap_8
X_2806_ clknet_leaf_4_clk _0440_ net39 VGND VGND VPWR VPWR tx_fifo.fifo\[7\]\[3\]
+ sky130_fd_sc_hd__edfxtp_1
X_2737_ clknet_leaf_42_clk _0491_ net48 VGND VGND VPWR VPWR tx_fifo.fifo\[1\]\[6\]
+ sky130_fd_sc_hd__edfxtp_1
XFILLER_0_14_355 VGND VGND VPWR VPWR sky130_fd_sc_hd__decap_8
Xfanout246 net251 VGND VGND VPWR VPWR net246 sky130_fd_sc_hd__clkbuf_2
X_1619_ _0821_ VGND VGND VPWR VPWR regs.int_pending sky130_fd_sc_hd__inv_1
X_2599_ clknet_leaf_24_clk _0320_ net81 VGND VGND VPWR VPWR rx_fifo.fifo\[3\]\[6\]
+ sky130_fd_sc_hd__edfxtp_1
Xfanout235 net237 VGND VGND VPWR VPWR net235 sky130_fd_sc_hd__clkbuf_4
Xfanout224 tx_fifo.head\[3\] VGND VGND VPWR VPWR net224 sky130_fd_sc_hd__clkbuf_4
Xfanout257 net261 VGND VGND VPWR VPWR net257 sky130_fd_sc_hd__clkbuf_4
XFILLER_0_52_417 VGND VGND VPWR VPWR sky130_fd_sc_hd__decap_3
XFILLER_0_37_447 VGND VGND VPWR VPWR sky130_fd_sc_hd__fill_1
XFILLER_0_9_393 VGND VGND VPWR VPWR sky130_fd_sc_hd__decap_4
XFILLER_0_60_461 VGND VGND VPWR VPWR sky130_fd_sc_hd__fill_2
XFILLER_0_32_141 VGND VGND VPWR VPWR sky130_fd_sc_hd__decap_4
XFILLER_0_17_193 VGND VGND VPWR VPWR sky130_fd_sc_hd__fill_1
X_1970_ net65 _0907_ VGND VGND VPWR VPWR _0487_ sky130_fd_sc_hd__nor2_1
XFILLER_0_55_299 VPWR VGND VPWR VGND sky130_ef_sc_hd__decap_12
XFILLER_0_55_266 VGND VGND VPWR VPWR sky130_fd_sc_hd__fill_2
XFILLER_0_51_461 VGND VGND VPWR VPWR sky130_fd_sc_hd__fill_2
XFILLER_0_11_97 VGND VGND VPWR VPWR sky130_fd_sc_hd__fill_1
X_2522_ net308 _1123_ _0614_ VGND VGND VPWR VPWR _1254_ sky130_fd_sc_hd__a21oi_1
X_1404_ net52 _0636_ _0640_ VGND VGND VPWR VPWR _0360_ sky130_fd_sc_hd__nor3_1
X_1335_ net214 net160 VGND VGND VPWR VPWR _0574_ sky130_fd_sc_hd__nor2_1
X_2453_ rx_fifo.fifo\[14\]\[7\] net170 net164 rx_fifo.fifo\[15\]\[7\] net166 rx_fifo.fifo\[2\]\[7\]
+ VGND VGND VPWR VPWR _1215_ sky130_fd_sc_hd__a222oi_1
X_2384_ tx_fifo.fifo\[9\]\[7\] _1001_ _1009_ tx_fifo.fifo\[15\]\[7\] VGND VGND VPWR
+ VPWR _1182_ sky130_fd_sc_hd__a22oi_1
X_1266_ tx_fifo.count\[1\] tx_fifo.count\[0\] VGND VGND VPWR VPWR _0511_ sky130_fd_sc_hd__nor2_1
Xinput2 addr[1] VGND VGND VPWR VPWR net2 sky130_fd_sc_hd__clkbuf_4
XFILLER_0_61_225 VPWR VGND VPWR VGND sky130_ef_sc_hd__decap_12
XFILLER_0_46_211 VPWR VGND VPWR VGND sky130_ef_sc_hd__decap_12
XFILLER_0_19_458 VGND VGND VPWR VPWR sky130_fd_sc_hd__decap_4
XFILLER_0_14_141 VGND VGND VPWR VPWR sky130_fd_sc_hd__decap_8
XFILLER_0_52_225 VGND VGND VPWR VPWR sky130_fd_sc_hd__decap_3
XFILLER_0_33_461 VGND VGND VPWR VPWR sky130_fd_sc_hd__fill_2
XFILLER_0_20_188 VGND VGND VPWR VPWR sky130_fd_sc_hd__decap_4
XFILLER_0_73_15 VPWR VGND VPWR VGND sky130_ef_sc_hd__decap_12
XFILLER_0_43_225 VPWR VGND VPWR VGND sky130_ef_sc_hd__decap_12
XFILLER_0_22_41 VGND VGND VPWR VPWR sky130_fd_sc_hd__decap_6
X_1884_ net72 _0895_ VGND VGND VPWR VPWR _0411_ sky130_fd_sc_hd__nor2_1
X_1953_ net66 _0905_ VGND VGND VPWR VPWR _0472_ sky130_fd_sc_hd__nor2_1
XFILLER_0_11_133 VGND VGND VPWR VPWR sky130_fd_sc_hd__fill_1
X_2505_ net272 _0957_ _1243_ _0943_ VGND VGND VPWR VPWR _0149_ sky130_fd_sc_hd__a22o_1
X_1318_ rx_fifo.fifo\[7\]\[8\] net172 net162 rx_fifo.fifo\[8\]\[8\] VGND VGND VPWR
+ VPWR _0558_ sky130_fd_sc_hd__a22o_1
XFILLER_0_47_82 VPWR VGND VPWR VGND sky130_ef_sc_hd__decap_12
X_2298_ net8 net32 _1135_ VGND VGND VPWR VPWR _0120_ sky130_fd_sc_hd__mux2_1
XFILLER_0_37_3 VGND VGND VPWR VPWR sky130_fd_sc_hd__decap_6
X_2436_ _0889_ net54 VGND VGND VPWR VPWR _0388_ sky130_fd_sc_hd__nor2_1
XFILLER_0_11_177 VGND VGND VPWR VPWR sky130_fd_sc_hd__fill_1
X_2367_ regs.tx_fifo_clear _0510_ _0877_ _0896_ VGND VGND VPWR VPWR _0000_ sky130_fd_sc_hd__nor4_1
XPHY_139 VGND VGND VPWR VPWR sky130_fd_sc_hd__decap_3
XPHY_128 VGND VGND VPWR VPWR sky130_fd_sc_hd__decap_3
XPHY_117 VGND VGND VPWR VPWR sky130_fd_sc_hd__decap_3
XPHY_106 VGND VGND VPWR VPWR sky130_fd_sc_hd__decap_3
XFILLER_0_34_269 VGND VGND VPWR VPWR sky130_fd_sc_hd__decap_8
XFILLER_0_6_193 VGND VGND VPWR VPWR sky130_fd_sc_hd__decap_3
Xmax_cap42 _0006_ VGND VGND VPWR VPWR net42 sky130_fd_sc_hd__clkbuf_2
XFILLER_0_72_309 VPWR VGND VPWR VGND sky130_ef_sc_hd__decap_12
XPHY_8 VGND VGND VPWR VPWR sky130_fd_sc_hd__decap_3
XFILLER_0_68_15 VPWR VGND VPWR VGND sky130_ef_sc_hd__decap_12
XFILLER_0_21_442 VGND VGND VPWR VPWR sky130_fd_sc_hd__decap_6
XTAP_659 VGND VPWR sky130_fd_sc_hd__tapvpwrvgnd_1
XTAP_648 VGND VPWR sky130_fd_sc_hd__tapvpwrvgnd_1
XTAP_637 VGND VPWR sky130_fd_sc_hd__tapvpwrvgnd_1
XTAP_626 VGND VPWR sky130_fd_sc_hd__tapvpwrvgnd_1
XTAP_615 VGND VPWR sky130_fd_sc_hd__tapvpwrvgnd_1
XTAP_604 VGND VPWR sky130_fd_sc_hd__tapvpwrvgnd_1
X_2221_ _0514_ _1096_ VGND VGND VPWR VPWR _1105_ sky130_fd_sc_hd__nand2b_1
X_2152_ net75 _1047_ VGND VGND VPWR VPWR _1048_ sky130_fd_sc_hd__nor2_1
X_2083_ rx.shift_reg\[5\] net314 _0987_ VGND VGND VPWR VPWR _0054_ sky130_fd_sc_hd__mux2_1
XFILLER_0_75_169 VPWR VGND VPWR VGND sky130_ef_sc_hd__decap_12
XFILLER_0_71_331 VGND VGND VPWR VPWR sky130_fd_sc_hd__decap_4
X_2985_ clknet_leaf_12_clk _0367_ net250 VGND VGND VPWR VPWR tx.baud_cnt\[4\] sky130_fd_sc_hd__dfrtp_1
X_1936_ net67 _0902_ VGND VGND VPWR VPWR _0456_ sky130_fd_sc_hd__nor2_1
X_1867_ net70 _0891_ VGND VGND VPWR VPWR _0394_ sky130_fd_sc_hd__nor2_1
XFILLER_0_16_203 VGND VGND VPWR VPWR sky130_fd_sc_hd__decap_6
X_1798_ net106 _0870_ VGND VGND VPWR VPWR _0316_ sky130_fd_sc_hd__nor2_1
XFILLER_0_3_130 VGND VGND VPWR VPWR sky130_fd_sc_hd__decap_6
X_2419_ net148 net91 VGND VGND VPWR VPWR _0314_ sky130_fd_sc_hd__nor2_1
XFILLER_0_38_29 VPWR VGND VPWR VGND sky130_ef_sc_hd__decap_12
XFILLER_0_30_283 VGND VGND VPWR VPWR sky130_fd_sc_hd__fill_1
XFILLER_0_57_125 VGND VGND VPWR VPWR sky130_fd_sc_hd__decap_4
XFILLER_0_70_27 VGND VGND VPWR VPWR sky130_fd_sc_hd__fill_1
XFILLER_0_57_169 VGND VGND VPWR VPWR sky130_fd_sc_hd__fill_1
XFILLER_0_57_158 VGND VGND VPWR VPWR sky130_fd_sc_hd__decap_8
XFILLER_0_53_331 VGND VGND VPWR VPWR sky130_fd_sc_hd__decap_4
X_1721_ net101 net155 VGND VGND VPWR VPWR _0236_ sky130_fd_sc_hd__nor2_1
XFILLER_0_5_417 VPWR VGND VPWR VGND sky130_ef_sc_hd__decap_12
X_2770_ clknet_leaf_0_clk _0468_ net44 VGND VGND VPWR VPWR tx_fifo.fifo\[4\]\[7\]
+ sky130_fd_sc_hd__edfxtp_1
Xhold107 tx.baud_cnt\[2\] VGND VGND VPWR VPWR net368 sky130_fd_sc_hd__dlygate4sd3_1
X_1652_ net210 net111 VGND VGND VPWR VPWR _0187_ sky130_fd_sc_hd__nor2_1
X_1583_ rx_fifo.fifo\[4\]\[2\] net173 net172 rx_fifo.fifo\[7\]\[2\] VGND VGND VPWR
+ VPWR _0788_ sky130_fd_sc_hd__a22oi_1
XTAP_423 VGND VPWR sky130_fd_sc_hd__tapvpwrvgnd_1
XTAP_412 VGND VPWR sky130_fd_sc_hd__tapvpwrvgnd_1
XTAP_401 VGND VPWR sky130_fd_sc_hd__tapvpwrvgnd_1
Xhold118 rx_fifo.count\[0\] VGND VGND VPWR VPWR net379 sky130_fd_sc_hd__dlygate4sd3_1
XFILLER_0_0_111 VGND VGND VPWR VPWR sky130_fd_sc_hd__fill_1
XFILLER_0_0_133 VGND VGND VPWR VPWR sky130_fd_sc_hd__fill_1
XTAP_489 VGND VPWR sky130_fd_sc_hd__tapvpwrvgnd_1
XTAP_478 VGND VPWR sky130_fd_sc_hd__tapvpwrvgnd_1
XTAP_467 VGND VPWR sky130_fd_sc_hd__tapvpwrvgnd_1
XTAP_456 VGND VPWR sky130_fd_sc_hd__tapvpwrvgnd_1
XTAP_445 VGND VPWR sky130_fd_sc_hd__tapvpwrvgnd_1
XTAP_434 VGND VPWR sky130_fd_sc_hd__tapvpwrvgnd_1
X_2204_ net125 _1084_ VGND VGND VPWR VPWR _1090_ sky130_fd_sc_hd__nor2_1
X_2135_ tx_fifo.fifo\[7\]\[4\] _0996_ _1002_ tx_fifo.fifo\[8\]\[4\] _1003_ tx_fifo.fifo\[1\]\[4\]
+ VGND VGND VPWR VPWR _1032_ sky130_fd_sc_hd__a222oi_1
XFILLER_0_76_445 VPWR VGND VPWR VGND sky130_ef_sc_hd__decap_12
XFILLER_0_48_114 VGND VGND VPWR VPWR sky130_fd_sc_hd__fill_1
XFILLER_0_44_83 VGND VGND VPWR VPWR sky130_fd_sc_hd__fill_1
X_2066_ rx.state\[2\] _0971_ VGND VGND VPWR VPWR _0975_ sky130_fd_sc_hd__nand2_1
X_2968_ clknet_leaf_10_clk _0170_ net244 VGND VGND VPWR VPWR rx.baud_cnt\[3\] sky130_fd_sc_hd__dfrtp_1
X_2899_ clknet_leaf_30_clk _0073_ net259 VGND VGND VPWR VPWR rx_fifo.count\[3\] sky130_fd_sc_hd__dfrtp_2
X_1919_ net69 _0900_ VGND VGND VPWR VPWR _0441_ sky130_fd_sc_hd__nor2_1
XFILLER_0_67_401 VGND VGND VPWR VPWR sky130_fd_sc_hd__decap_8
XFILLER_0_67_445 VGND VGND VPWR VPWR sky130_fd_sc_hd__decap_3
XFILLER_0_54_128 VGND VGND VPWR VPWR sky130_fd_sc_hd__fill_1
XFILLER_0_39_169 VGND VGND VPWR VPWR sky130_fd_sc_hd__decap_3
XFILLER_0_35_375 VGND VGND VPWR VPWR sky130_fd_sc_hd__decap_8
XFILLER_0_62_194 VGND VGND VPWR VPWR sky130_fd_sc_hd__fill_2
XFILLER_0_62_172 VGND VGND VPWR VPWR sky130_fd_sc_hd__fill_2
XFILLER_0_50_389 VGND VGND VPWR VPWR sky130_fd_sc_hd__decap_6
XFILLER_0_10_209 VPWR VGND VPWR VGND sky130_ef_sc_hd__decap_12
XFILLER_0_77_209 VPWR VGND VPWR VGND sky130_ef_sc_hd__decap_12
X_2684_ clknet_leaf_25_clk _0251_ net93 VGND VGND VPWR VPWR rx_fifo.fifo\[9\]\[3\]
+ sky130_fd_sc_hd__edfxtp_1
XFILLER_0_41_334 VGND VGND VPWR VPWR sky130_fd_sc_hd__fill_2
X_2753_ clknet_leaf_7_clk _0403_ net46 VGND VGND VPWR VPWR tx_fifo.fifo\[12\]\[6\]
+ sky130_fd_sc_hd__edfxtp_1
X_1704_ net113 net156 VGND VGND VPWR VPWR _0232_ sky130_fd_sc_hd__nor2_1
XFILLER_0_30_85 VGND VGND VPWR VPWR sky130_fd_sc_hd__fill_1
XFILLER_0_30_41 VGND VGND VPWR VPWR sky130_fd_sc_hd__decap_4
XFILLER_0_26_375 VPWR VGND VPWR VGND sky130_ef_sc_hd__decap_12
XFILLER_0_5_225 VPWR VGND VPWR VGND sky130_ef_sc_hd__decap_12
X_2822_ clknet_leaf_41_clk _0424_ net37 VGND VGND VPWR VPWR tx_fifo.fifo\[9\]\[3\]
+ sky130_fd_sc_hd__edfxtp_1
XFILLER_0_14_97 VGND VGND VPWR VPWR sky130_fd_sc_hd__decap_4
X_1566_ rx_fifo.fifo\[4\]\[3\] net173 net171 rx_fifo.fifo\[11\]\[3\] net163 rx_fifo.fifo\[5\]\[3\]
+ VGND VGND VPWR VPWR _0772_ sky130_fd_sc_hd__a222oi_1
X_1497_ rx.baud_cnt\[3\] _0652_ VGND VGND VPWR VPWR _0710_ sky130_fd_sc_hd__xnor2_1
X_1635_ _0714_ _0835_ _0825_ _0822_ _0763_ VGND VGND VPWR VPWR _0836_ sky130_fd_sc_hd__o2111ai_2
XFILLER_0_41_389 VGND VGND VPWR VPWR sky130_fd_sc_hd__decap_3
XTAP_220 VGND VPWR sky130_fd_sc_hd__tapvpwrvgnd_1
XTAP_231 VGND VPWR sky130_fd_sc_hd__tapvpwrvgnd_1
XTAP_242 VGND VPWR sky130_fd_sc_hd__tapvpwrvgnd_1
XTAP_253 VGND VPWR sky130_fd_sc_hd__tapvpwrvgnd_1
XTAP_264 VGND VPWR sky130_fd_sc_hd__tapvpwrvgnd_1
XTAP_275 VGND VPWR sky130_fd_sc_hd__tapvpwrvgnd_1
XFILLER_0_68_209 VGND VGND VPWR VPWR sky130_fd_sc_hd__fill_1
XFILLER_0_55_93 VGND VGND VPWR VPWR sky130_fd_sc_hd__decap_4
XFILLER_0_55_82 VGND VGND VPWR VPWR sky130_fd_sc_hd__fill_2
X_2118_ tx_fifo.fifo\[13\]\[6\] _0999_ net192 tx_fifo.fifo\[9\]\[6\] _1014_ VGND VGND
+ VPWR VPWR _1017_ sky130_fd_sc_hd__a221oi_1
XTAP_286 VGND VPWR sky130_fd_sc_hd__tapvpwrvgnd_1
XTAP_297 VGND VPWR sky130_fd_sc_hd__tapvpwrvgnd_1
X_2049_ _0944_ _0964_ rx.bit_cnt\[0\] VGND VGND VPWR VPWR _0966_ sky130_fd_sc_hd__a21oi_1
XFILLER_0_76_275 VGND VGND VPWR VPWR sky130_fd_sc_hd__fill_2
XFILLER_0_76_253 VPWR VGND VPWR VGND sky130_ef_sc_hd__decap_12
XFILLER_0_64_415 VGND VGND VPWR VPWR sky130_fd_sc_hd__fill_1
Xfanout68 _0883_ VGND VGND VPWR VPWR net68 sky130_fd_sc_hd__clkbuf_4
XFILLER_0_17_375 VGND VGND VPWR VPWR sky130_fd_sc_hd__fill_2
XFILLER_0_17_386 VGND VGND VPWR VPWR sky130_fd_sc_hd__decap_6
Xmax_cap190 _1003_ VGND VGND VPWR VPWR net190 sky130_fd_sc_hd__clkbuf_2
XFILLER_0_2_206 VGND VGND VPWR VPWR sky130_fd_sc_hd__fill_2
XFILLER_0_76_15 VPWR VGND VPWR VGND sky130_ef_sc_hd__decap_12
X_1420_ net53 _0631_ _0648_ VGND VGND VPWR VPWR _0367_ sky130_fd_sc_hd__nor3_1
X_1351_ _0566_ _0568_ VGND VGND VPWR VPWR _0590_ sky130_fd_sc_hd__nand2_1
XFILLER_0_50_197 VGND VGND VPWR VPWR sky130_fd_sc_hd__fill_2
X_1282_ rx_fifo.head\[0\] rx_fifo.head\[1\] _0523_ VGND VGND VPWR VPWR _0524_ sky130_fd_sc_hd__nor3_1
XFILLER_0_73_223 VGND VGND VPWR VPWR sky130_fd_sc_hd__fill_1
XFILLER_0_58_253 VGND VGND VPWR VPWR sky130_fd_sc_hd__decap_3
XFILLER_0_46_459 VGND VGND VPWR VPWR sky130_fd_sc_hd__decap_4
XFILLER_0_41_40 VPWR VGND VPWR VGND sky130_ef_sc_hd__decap_12
X_2805_ clknet_leaf_39_clk _0439_ net39 VGND VGND VPWR VPWR tx_fifo.fifo\[7\]\[2\]
+ sky130_fd_sc_hd__edfxtp_1
XFILLER_0_25_85 VGND VGND VPWR VPWR sky130_fd_sc_hd__fill_2
XFILLER_0_67_3 VGND VGND VPWR VPWR sky130_fd_sc_hd__fill_2
XFILLER_0_61_429 VGND VGND VPWR VPWR sky130_fd_sc_hd__decap_6
X_2667_ clknet_leaf_16_clk _0278_ net96 VGND VGND VPWR VPWR rx_fifo.fifo\[7\]\[8\]
+ sky130_fd_sc_hd__edfxtp_1
X_1618_ net349 net34 _0797_ VGND VGND VPWR VPWR _0821_ sky130_fd_sc_hd__a21oi_2
X_2736_ clknet_leaf_43_clk _0490_ net48 VGND VGND VPWR VPWR tx_fifo.fifo\[1\]\[5\]
+ sky130_fd_sc_hd__edfxtp_1
X_2598_ clknet_leaf_20_clk _0319_ net81 VGND VGND VPWR VPWR rx_fifo.fifo\[3\]\[5\]
+ sky130_fd_sc_hd__edfxtp_1
XFILLER_0_66_70 VPWR VGND VPWR VGND sky130_ef_sc_hd__decap_12
Xfanout214 _0567_ VGND VGND VPWR VPWR net214 sky130_fd_sc_hd__clkbuf_4
X_1549_ rx_fifo.fifo\[0\]\[4\] net215 net170 rx_fifo.fifo\[14\]\[4\] rx_fifo.fifo\[2\]\[4\]
+ net166 VGND VGND VPWR VPWR _0756_ sky130_fd_sc_hd__a222oi_1
Xfanout236 net237 VGND VGND VPWR VPWR net236 sky130_fd_sc_hd__buf_2
Xfanout247 net251 VGND VGND VPWR VPWR net247 sky130_fd_sc_hd__clkbuf_4
Xfanout225 tx_fifo.head\[3\] VGND VGND VPWR VPWR net225 sky130_fd_sc_hd__clkbuf_2
Xfanout258 net261 VGND VGND VPWR VPWR net258 sky130_fd_sc_hd__clkbuf_4
XFILLER_0_37_437 VGND VGND VPWR VPWR sky130_fd_sc_hd__fill_1
XFILLER_0_20_337 VGND VGND VPWR VPWR sky130_fd_sc_hd__fill_1
XFILLER_0_20_359 VGND VGND VPWR VPWR sky130_fd_sc_hd__decap_4
XFILLER_0_46_29 VGND VGND VPWR VPWR sky130_fd_sc_hd__decap_3
XFILLER_0_15_109 VGND VGND VPWR VPWR sky130_fd_sc_hd__decap_3
XFILLER_0_70_248 VGND VGND VPWR VPWR sky130_fd_sc_hd__decap_4
XFILLER_0_55_278 VGND VGND VPWR VPWR sky130_fd_sc_hd__fill_2
XFILLER_0_23_120 VPWR VGND VPWR VGND sky130_ef_sc_hd__decap_12
XFILLER_0_11_65 VGND VGND VPWR VPWR sky130_fd_sc_hd__fill_1
XFILLER_0_11_348 VGND VGND VPWR VPWR sky130_fd_sc_hd__fill_1
X_2521_ tx.shift_reg\[1\] _1116_ _1122_ net321 VGND VGND VPWR VPWR _1253_ sky130_fd_sc_hd__o22a_1
X_1403_ tx.baud_cnt\[11\] _0635_ net373 VGND VGND VPWR VPWR _0640_ sky130_fd_sc_hd__a21oi_1
X_1334_ divisor\[8\] net214 _0569_ VGND VGND VPWR VPWR _0573_ sky130_fd_sc_hd__nor3_1
X_2452_ rx_fifo.fifo\[0\]\[7\] net215 net161 rx_fifo.fifo\[9\]\[7\] VGND VGND VPWR
+ VPWR _1214_ sky130_fd_sc_hd__a22oi_1
X_2383_ tx_fifo.fifo\[7\]\[7\] _0996_ _0998_ tx_fifo.fifo\[10\]\[7\] VGND VGND VPWR
+ VPWR _1181_ sky130_fd_sc_hd__a22oi_1
X_1265_ net240 VGND VGND VPWR VPWR _0510_ sky130_fd_sc_hd__inv_1
Xinput3 addr[2] VGND VGND VPWR VPWR net3 sky130_fd_sc_hd__buf_2
XFILLER_0_61_237 VGND VGND VPWR VPWR sky130_fd_sc_hd__decap_6
XFILLER_0_46_223 VGND VGND VPWR VPWR sky130_fd_sc_hd__decap_4
XFILLER_0_34_429 VPWR VGND VPWR VGND sky130_ef_sc_hd__decap_12
XFILLER_0_77_91 VPWR VGND VPWR VGND sky130_ef_sc_hd__decap_12
X_2719_ clknet_leaf_42_clk _0409_ net50 VGND VGND VPWR VPWR tx_fifo.fifo\[11\]\[4\]
+ sky130_fd_sc_hd__edfxtp_1
XFILLER_0_14_197 VGND VGND VPWR VPWR sky130_fd_sc_hd__decap_4
XFILLER_0_69_337 VPWR VGND VPWR VGND sky130_ef_sc_hd__decap_12
XFILLER_0_37_267 VPWR VGND VPWR VGND sky130_ef_sc_hd__decap_12
XFILLER_0_73_27 VPWR VGND VPWR VGND sky130_ef_sc_hd__decap_12
XFILLER_0_43_237 VGND VGND VPWR VPWR sky130_fd_sc_hd__decap_4
XFILLER_0_28_201 VGND VGND VPWR VPWR sky130_fd_sc_hd__fill_1
X_1883_ tx_fifo.tail\[1\] net223 net204 VGND VGND VPWR VPWR _0895_ sky130_fd_sc_hd__nand3_4
XFILLER_0_7_128 VGND VGND VPWR VPWR sky130_fd_sc_hd__fill_2
X_1952_ net68 _0905_ VGND VGND VPWR VPWR _0473_ sky130_fd_sc_hd__nor2_1
XFILLER_0_51_270 VGND VGND VPWR VPWR sky130_fd_sc_hd__decap_4
XFILLER_0_11_101 VGND VGND VPWR VPWR sky130_fd_sc_hd__decap_8
X_2435_ _0879_ net54 VGND VGND VPWR VPWR _0380_ sky130_fd_sc_hd__nor2_1
X_2504_ _0963_ _1242_ VGND VGND VPWR VPWR _1243_ sky130_fd_sc_hd__nor2_1
X_2297_ net9 net21 _1135_ VGND VGND VPWR VPWR _0119_ sky130_fd_sc_hd__mux2_1
XFILLER_0_47_94 VPWR VGND VPWR VGND sky130_ef_sc_hd__decap_12
X_1317_ rx_fifo.fifo\[11\]\[8\] net171 net167 rx_fifo.fifo\[10\]\[8\] rx_fifo.fifo\[9\]\[8\]
+ net161 VGND VGND VPWR VPWR _0557_ sky130_fd_sc_hd__a222oi_1
X_2366_ net219 _0897_ net58 VGND VGND VPWR VPWR _0001_ sky130_fd_sc_hd__nor3_2
XFILLER_0_66_307 VGND VGND VPWR VPWR sky130_fd_sc_hd__fill_1
XPHY_129 VGND VGND VPWR VPWR sky130_fd_sc_hd__decap_3
XPHY_118 VGND VGND VPWR VPWR sky130_fd_sc_hd__decap_3
XPHY_107 VGND VGND VPWR VPWR sky130_fd_sc_hd__decap_3
XFILLER_0_19_201 VGND VGND VPWR VPWR sky130_fd_sc_hd__fill_1
XFILLER_0_19_212 VGND VGND VPWR VPWR sky130_fd_sc_hd__decap_8
XFILLER_0_69_167 VGND VGND VPWR VPWR sky130_fd_sc_hd__fill_1
Xmax_cap43 _0007_ VGND VGND VPWR VPWR net43 sky130_fd_sc_hd__buf_2
XPHY_9 VGND VGND VPWR VPWR sky130_fd_sc_hd__decap_3
XFILLER_0_65_340 VGND VGND VPWR VPWR sky130_fd_sc_hd__decap_8
XFILLER_0_68_27 VGND VGND VPWR VPWR sky130_fd_sc_hd__fill_1
XTAP_616 VGND VPWR sky130_fd_sc_hd__tapvpwrvgnd_1
XTAP_605 VGND VPWR sky130_fd_sc_hd__tapvpwrvgnd_1
XFILLER_0_33_281 VPWR VGND VPWR VGND sky130_ef_sc_hd__decap_12
XFILLER_0_21_421 VGND VGND VPWR VPWR sky130_fd_sc_hd__fill_1
XTAP_649 VGND VPWR sky130_fd_sc_hd__tapvpwrvgnd_1
XTAP_638 VGND VPWR sky130_fd_sc_hd__tapvpwrvgnd_1
XTAP_627 VGND VPWR sky130_fd_sc_hd__tapvpwrvgnd_1
X_2220_ rx_fifo.count\[1\] _1092_ VGND VGND VPWR VPWR _1104_ sky130_fd_sc_hd__nand2_1
X_2151_ net313 net194 net187 tx_fifo.fifo\[6\]\[3\] _1046_ VGND VGND VPWR VPWR _1047_
+ sky130_fd_sc_hd__a221oi_2
X_2082_ rx.shift_reg\[6\] net281 _0987_ VGND VGND VPWR VPWR _0053_ sky130_fd_sc_hd__mux2_1
XFILLER_0_75_126 VGND VGND VPWR VPWR sky130_fd_sc_hd__fill_1
X_2984_ clknet_leaf_13_clk _0366_ net249 VGND VGND VPWR VPWR tx.baud_cnt\[3\] sky130_fd_sc_hd__dfrtp_1
XFILLER_0_48_307 VGND VGND VPWR VPWR sky130_fd_sc_hd__fill_1
X_1797_ net107 net148 VGND VGND VPWR VPWR _0317_ sky130_fd_sc_hd__nor2_1
X_1935_ net69 _0902_ VGND VGND VPWR VPWR _0457_ sky130_fd_sc_hd__nor2_1
X_1866_ net72 _0891_ VGND VGND VPWR VPWR _0395_ sky130_fd_sc_hd__nor2_1
XFILLER_0_12_421 VGND VGND VPWR VPWR sky130_fd_sc_hd__decap_4
X_2418_ net328 divisor\[15\] net182 VGND VGND VPWR VPWR _0134_ sky130_fd_sc_hd__mux2_1
XFILLER_0_3_186 VPWR VGND VPWR VGND sky130_ef_sc_hd__decap_12
X_2349_ net124 net154 net180 VGND VGND VPWR VPWR _0017_ sky130_fd_sc_hd__nor3_1
XFILLER_0_47_362 VGND VGND VPWR VPWR sky130_fd_sc_hd__fill_1
XFILLER_0_39_329 VGND VGND VPWR VPWR sky130_fd_sc_hd__fill_2
XFILLER_0_62_365 VGND VGND VPWR VPWR sky130_fd_sc_hd__fill_1
XFILLER_0_30_251 VGND VGND VPWR VPWR sky130_fd_sc_hd__fill_1
XFILLER_0_15_281 VGND VGND VPWR VPWR sky130_fd_sc_hd__fill_1
XFILLER_0_72_118 VGND VGND VPWR VPWR sky130_fd_sc_hd__fill_1
Xhold108 _0650_ VGND VGND VPWR VPWR net369 sky130_fd_sc_hd__dlygate4sd3_1
XFILLER_0_53_343 VGND VGND VPWR VPWR sky130_fd_sc_hd__decap_4
XFILLER_0_38_362 VGND VGND VPWR VPWR sky130_fd_sc_hd__fill_2
X_1720_ net104 _0861_ VGND VGND VPWR VPWR _0238_ sky130_fd_sc_hd__nor2_1
X_1651_ regs.rx_data\[5\] net125 VGND VGND VPWR VPWR _0847_ sky130_fd_sc_hd__nand2_1
XFILLER_0_5_429 VPWR VGND VPWR VGND sky130_ef_sc_hd__decap_12
X_1582_ _0785_ _0786_ VGND VGND VPWR VPWR _0787_ sky130_fd_sc_hd__nand2_1
XTAP_457 VGND VPWR sky130_fd_sc_hd__tapvpwrvgnd_1
XTAP_446 VGND VPWR sky130_fd_sc_hd__tapvpwrvgnd_1
XTAP_435 VGND VPWR sky130_fd_sc_hd__tapvpwrvgnd_1
XTAP_424 VGND VPWR sky130_fd_sc_hd__tapvpwrvgnd_1
XTAP_413 VGND VPWR sky130_fd_sc_hd__tapvpwrvgnd_1
XTAP_402 VGND VPWR sky130_fd_sc_hd__tapvpwrvgnd_1
XFILLER_0_0_189 VGND VGND VPWR VPWR sky130_fd_sc_hd__decap_6
XTAP_479 VGND VPWR sky130_fd_sc_hd__tapvpwrvgnd_1
XTAP_468 VGND VPWR sky130_fd_sc_hd__tapvpwrvgnd_1
X_2203_ net222 _1085_ _1089_ VGND VGND VPWR VPWR _0072_ sky130_fd_sc_hd__nor3_1
X_2134_ tx_fifo.fifo\[5\]\[4\] net388 _0999_ tx_fifo.fifo\[13\]\[4\] VGND VGND VPWR
+ VPWR _1031_ sky130_fd_sc_hd__a22oi_1
X_2065_ _0951_ _0973_ VGND VGND VPWR VPWR _0974_ sky130_fd_sc_hd__nand2_1
XFILLER_0_21_7 VGND VGND VPWR VPWR sky130_fd_sc_hd__decap_4
XFILLER_0_76_457 VGND VGND VPWR VPWR sky130_fd_sc_hd__decap_6
XFILLER_0_76_413 VGND VGND VPWR VPWR sky130_fd_sc_hd__decap_6
X_2967_ clknet_leaf_10_clk _0169_ net244 VGND VGND VPWR VPWR rx.baud_cnt\[2\] sky130_fd_sc_hd__dfrtp_1
XFILLER_0_60_83 VGND VGND VPWR VPWR sky130_fd_sc_hd__fill_1
XFILLER_0_44_321 VGND VGND VPWR VPWR sky130_fd_sc_hd__decap_4
XFILLER_0_71_173 VGND VGND VPWR VPWR sky130_fd_sc_hd__fill_1
XFILLER_0_69_92 VPWR VGND VPWR VGND sky130_ef_sc_hd__decap_12
XFILLER_0_44_365 VGND VGND VPWR VPWR sky130_fd_sc_hd__decap_3
X_1849_ regs.tx_data\[2\] _0876_ VGND VGND VPWR VPWR _0885_ sky130_fd_sc_hd__nand2_1
X_2898_ clknet_leaf_30_clk _0074_ net259 VGND VGND VPWR VPWR rx_fifo.count\[2\] sky130_fd_sc_hd__dfrtp_4
X_1918_ net71 _0900_ VGND VGND VPWR VPWR _0442_ sky130_fd_sc_hd__nor2_1
Xclkbuf_leaf_20_clk clknet_2_3__leaf_clk VGND VGND VPWR VPWR clknet_leaf_20_clk sky130_fd_sc_hd__clkbuf_16
XFILLER_0_35_387 VGND VGND VPWR VPWR sky130_fd_sc_hd__decap_4
XFILLER_0_35_343 VGND VGND VPWR VPWR sky130_fd_sc_hd__fill_1
XFILLER_0_73_449 VPWR VGND VPWR VGND sky130_ef_sc_hd__decap_12
XFILLER_0_58_413 VGND VGND VPWR VPWR sky130_fd_sc_hd__decap_6
XFILLER_0_5_204 VGND VGND VPWR VPWR sky130_fd_sc_hd__decap_8
X_2821_ clknet_leaf_42_clk _0423_ net37 VGND VGND VPWR VPWR tx_fifo.fifo\[9\]\[2\]
+ sky130_fd_sc_hd__edfxtp_1
Xclkbuf_leaf_11_clk clknet_2_2__leaf_clk VGND VGND VPWR VPWR clknet_leaf_11_clk sky130_fd_sc_hd__clkbuf_16
X_1634_ divisor\[0\] net237 _0716_ _0834_ VGND VGND VPWR VPWR _0835_ sky130_fd_sc_hd__a22oi_2
X_1703_ net115 net156 VGND VGND VPWR VPWR _0233_ sky130_fd_sc_hd__nor2_1
XFILLER_0_53_195 VGND VGND VPWR VPWR sky130_fd_sc_hd__fill_2
X_2683_ clknet_leaf_27_clk _0250_ net93 VGND VGND VPWR VPWR rx_fifo.fifo\[9\]\[2\]
+ sky130_fd_sc_hd__edfxtp_1
X_2752_ clknet_leaf_2_clk _0402_ net46 VGND VGND VPWR VPWR tx_fifo.fifo\[12\]\[5\]
+ sky130_fd_sc_hd__edfxtp_1
XFILLER_0_26_387 VGND VGND VPWR VPWR sky130_fd_sc_hd__fill_2
XFILLER_0_26_365 VGND VGND VPWR VPWR sky130_fd_sc_hd__decap_4
XFILLER_0_5_237 VPWR VGND VPWR VGND sky130_ef_sc_hd__decap_12
XFILLER_0_5_215 VGND VGND VPWR VPWR sky130_fd_sc_hd__decap_8
X_1565_ rx_fifo.fifo\[13\]\[3\] net175 net168 rx_fifo.fifo\[1\]\[3\] net169 rx_fifo.fifo\[6\]\[3\]
+ VGND VGND VPWR VPWR _0771_ sky130_fd_sc_hd__a222oi_1
X_1496_ _0653_ net74 _0709_ VGND VGND VPWR VPWR _0171_ sky130_fd_sc_hd__nor3_1
XFILLER_0_39_40 VPWR VGND VPWR VGND sky130_ef_sc_hd__decap_12
XTAP_210 VGND VPWR sky130_fd_sc_hd__tapvpwrvgnd_1
XTAP_221 VGND VPWR sky130_fd_sc_hd__tapvpwrvgnd_1
XTAP_232 VGND VPWR sky130_fd_sc_hd__tapvpwrvgnd_1
XTAP_243 VGND VPWR sky130_fd_sc_hd__tapvpwrvgnd_1
XTAP_254 VGND VPWR sky130_fd_sc_hd__tapvpwrvgnd_1
XTAP_265 VGND VPWR sky130_fd_sc_hd__tapvpwrvgnd_1
XTAP_276 VGND VPWR sky130_fd_sc_hd__tapvpwrvgnd_1
XTAP_287 VGND VPWR sky130_fd_sc_hd__tapvpwrvgnd_1
XTAP_298 VGND VPWR sky130_fd_sc_hd__tapvpwrvgnd_1
XFILLER_0_55_50 VGND VGND VPWR VPWR sky130_fd_sc_hd__fill_1
XFILLER_0_49_457 VGND VGND VPWR VPWR sky130_fd_sc_hd__decap_6
X_2117_ tx_fifo.fifo\[1\]\[6\] net189 net186 tx_fifo.fifo\[6\]\[6\] _1015_ VGND VGND
+ VPWR VPWR _1016_ sky130_fd_sc_hd__a221oi_1
X_2048_ _0504_ _0956_ _0965_ VGND VGND VPWR VPWR _0042_ sky130_fd_sc_hd__o21ai_0
XFILLER_0_76_265 VGND VGND VPWR VPWR sky130_fd_sc_hd__decap_8
XFILLER_0_44_162 VGND VGND VPWR VPWR sky130_fd_sc_hd__decap_4
Xfanout69 _0883_ VGND VGND VPWR VPWR net69 sky130_fd_sc_hd__clkbuf_2
XFILLER_0_36_129 VGND VGND VPWR VPWR sky130_fd_sc_hd__fill_2
XFILLER_0_32_302 VGND VGND VPWR VPWR sky130_fd_sc_hd__fill_2
Xfanout58 _1166_ VGND VGND VPWR VPWR net58 sky130_fd_sc_hd__buf_4
Xmax_cap191 _1002_ VGND VGND VPWR VPWR net191 sky130_fd_sc_hd__clkbuf_2
XFILLER_0_55_449 VPWR VGND VPWR VGND sky130_ef_sc_hd__decap_12
XFILLER_0_23_379 VPWR VGND VPWR VGND sky130_ef_sc_hd__decap_12
XFILLER_0_23_357 VGND VGND VPWR VPWR sky130_fd_sc_hd__fill_2
XFILLER_0_76_27 VGND VGND VPWR VPWR sky130_fd_sc_hd__fill_1
X_1350_ divisor\[4\] divisor\[5\] _0567_ VGND VGND VPWR VPWR _0589_ sky130_fd_sc_hd__nor3_1
X_1281_ rx_fifo.head\[3\] net234 VGND VGND VPWR VPWR _0523_ sky130_fd_sc_hd__nand2b_1
Xclkbuf_leaf_0_clk clknet_2_0__leaf_clk VGND VGND VPWR VPWR clknet_leaf_0_clk sky130_fd_sc_hd__clkbuf_16
XFILLER_0_58_287 VGND VGND VPWR VPWR sky130_fd_sc_hd__fill_1
XFILLER_0_46_416 VGND VGND VPWR VPWR sky130_fd_sc_hd__fill_1
XFILLER_0_41_52 VGND VGND VPWR VPWR sky130_fd_sc_hd__decap_4
X_2804_ clknet_leaf_38_clk _0438_ net39 VGND VGND VPWR VPWR tx_fifo.fifo\[7\]\[1\]
+ sky130_fd_sc_hd__edfxtp_1
X_2597_ clknet_leaf_20_clk _0318_ net81 VGND VGND VPWR VPWR rx_fifo.fifo\[3\]\[4\]
+ sky130_fd_sc_hd__edfxtp_1
X_1617_ net4 _0820_ VGND VGND VPWR VPWR net25 sky130_fd_sc_hd__and2_1
X_2666_ clknet_leaf_17_clk _0277_ _0019_ VGND VGND VPWR VPWR rx_fifo.fifo\[7\]\[7\]
+ sky130_fd_sc_hd__edfxtp_1
X_2735_ clknet_leaf_4_clk _0489_ _0012_ VGND VGND VPWR VPWR tx_fifo.fifo\[1\]\[4\]
+ sky130_fd_sc_hd__edfxtp_1
X_1548_ rx_fifo.fifo\[4\]\[4\] net173 net171 rx_fifo.fifo\[11\]\[4\] _0754_ VGND VGND
+ VPWR VPWR _0755_ sky130_fd_sc_hd__a221oi_1
XFILLER_0_66_82 VGND VGND VPWR VPWR sky130_fd_sc_hd__fill_2
Xfanout248 net251 VGND VGND VPWR VPWR net248 sky130_fd_sc_hd__buf_2
X_1479_ _0671_ _0697_ _0699_ _0667_ VGND VGND VPWR VPWR _0700_ sky130_fd_sc_hd__nand4b_4
Xfanout237 regs.dlab VGND VGND VPWR VPWR net237 sky130_fd_sc_hd__clkbuf_4
Xfanout259 net260 VGND VGND VPWR VPWR net259 sky130_fd_sc_hd__clkbuf_4
Xfanout215 _0522_ VGND VGND VPWR VPWR net215 sky130_fd_sc_hd__clkbuf_4
XFILLER_0_5_41 VPWR VGND VPWR VGND sky130_ef_sc_hd__decap_12
Xfanout226 tx_fifo.head\[2\] VGND VGND VPWR VPWR net226 sky130_fd_sc_hd__clkbuf_4
XFILLER_0_64_235 VGND VGND VPWR VPWR sky130_fd_sc_hd__decap_8
XFILLER_0_49_254 VGND VGND VPWR VPWR sky130_fd_sc_hd__fill_1
XFILLER_0_37_449 VGND VGND VPWR VPWR sky130_fd_sc_hd__fill_1
XFILLER_0_9_340 VGND VGND VPWR VPWR sky130_fd_sc_hd__decap_6
XFILLER_0_9_351 VPWR VGND VPWR VGND sky130_ef_sc_hd__decap_12
XFILLER_0_45_460 VGND VGND VPWR VPWR sky130_fd_sc_hd__decap_3
XFILLER_0_32_154 VGND VGND VPWR VPWR sky130_fd_sc_hd__fill_2
XFILLER_0_1_3 VPWR VGND VPWR VGND sky130_ef_sc_hd__decap_12
XFILLER_0_13_390 VGND VGND VPWR VPWR sky130_fd_sc_hd__fill_2
XFILLER_0_36_460 VGND VGND VPWR VPWR sky130_fd_sc_hd__decap_3
X_1402_ net52 _0637_ _0639_ VGND VGND VPWR VPWR _0361_ sky130_fd_sc_hd__nor3_1
X_2451_ rx_fifo.fifo\[7\]\[7\] _0525_ net171 rx_fifo.fifo\[11\]\[7\] net165 rx_fifo.fifo\[12\]\[7\]
+ VGND VGND VPWR VPWR _1213_ sky130_fd_sc_hd__a222oi_1
XFILLER_0_51_430 VPWR VGND VPWR VGND sky130_ef_sc_hd__decap_12
XFILLER_0_23_165 VGND VGND VPWR VPWR sky130_fd_sc_hd__decap_3
XFILLER_0_23_132 VGND VGND VPWR VPWR sky130_fd_sc_hd__decap_8
XFILLER_0_11_44 VGND VGND VPWR VPWR sky130_fd_sc_hd__decap_8
X_2520_ net35 _1251_ VGND VGND VPWR VPWR _1252_ sky130_fd_sc_hd__nand2_1
X_1333_ net214 _0569_ VGND VGND VPWR VPWR _0572_ sky130_fd_sc_hd__nor2_1
Xinput4 rd_en VGND VGND VPWR VPWR net4 sky130_fd_sc_hd__clkbuf_4
X_1264_ net334 VGND VGND VPWR VPWR _0509_ sky130_fd_sc_hd__inv_1
X_2382_ tx_fifo.fifo\[8\]\[7\] _1002_ net383 tx_fifo.fifo\[6\]\[7\] tx_fifo.fifo\[3\]\[7\]
+ net384 VGND VGND VPWR VPWR _1180_ sky130_fd_sc_hd__a222oi_1
XFILLER_0_36_85 VGND VGND VPWR VPWR sky130_fd_sc_hd__decap_4
Xclkbuf_2_1__f_clk clknet_0_clk VGND VGND VPWR VPWR clknet_2_1__leaf_clk sky130_fd_sc_hd__clkbuf_16
XFILLER_0_19_405 VGND VGND VPWR VPWR sky130_fd_sc_hd__decap_4
XFILLER_0_46_268 VPWR VGND VPWR VGND sky130_ef_sc_hd__decap_12
X_2718_ clknet_leaf_41_clk _0408_ net50 VGND VGND VPWR VPWR tx_fifo.fifo\[11\]\[3\]
+ sky130_fd_sc_hd__edfxtp_1
XFILLER_0_6_321 VPWR VGND VPWR VGND sky130_ef_sc_hd__decap_12
XFILLER_0_6_365 VGND VGND VPWR VPWR sky130_fd_sc_hd__decap_4
XFILLER_0_77_81 VGND VGND VPWR VPWR sky130_fd_sc_hd__decap_3
X_2649_ clknet_leaf_22_clk _0205_ net97 VGND VGND VPWR VPWR rx_fifo.fifo\[13\]\[1\]
+ sky130_fd_sc_hd__edfxtp_1
XFILLER_0_69_349 VGND VGND VPWR VPWR sky130_fd_sc_hd__fill_2
XFILLER_0_77_393 VPWR VGND VPWR VGND sky130_ef_sc_hd__decap_12
XFILLER_0_37_279 VGND VGND VPWR VPWR sky130_fd_sc_hd__fill_1
XFILLER_0_73_39 VPWR VGND VPWR VGND sky130_ef_sc_hd__decap_12
XFILLER_0_24_441 VGND VGND VPWR VPWR sky130_fd_sc_hd__fill_1
X_1951_ net71 _0905_ VGND VGND VPWR VPWR _0474_ sky130_fd_sc_hd__nor2_1
XFILLER_0_3_335 VGND VGND VPWR VPWR sky130_fd_sc_hd__fill_1
XFILLER_0_16_419 VGND VGND VPWR VPWR sky130_fd_sc_hd__fill_1
X_1882_ tx_fifo.tail\[3\] tx_fifo.tail\[2\] VGND VGND VPWR VPWR _0894_ sky130_fd_sc_hd__lpflow_isobufsrc_1
X_2434_ regs.tx_data\[7\] net76 VGND VGND VPWR VPWR _1202_ sky130_fd_sc_hd__nand2_1
X_2365_ net219 _0898_ net59 VGND VGND VPWR VPWR _0002_ sky130_fd_sc_hd__nor3_2
X_2503_ _0505_ _1241_ VGND VGND VPWR VPWR _1242_ sky130_fd_sc_hd__xnor2_1
X_2296_ net10 net367 _1135_ VGND VGND VPWR VPWR _0118_ sky130_fd_sc_hd__mux2_1
X_1316_ net179 _0556_ VGND VGND VPWR VPWR net19 sky130_fd_sc_hd__nor2_2
XPHY_119 VGND VGND VPWR VPWR sky130_fd_sc_hd__decap_3
XPHY_108 VGND VGND VPWR VPWR sky130_fd_sc_hd__decap_3
XFILLER_0_19_268 VGND VGND VPWR VPWR sky130_fd_sc_hd__decap_8
XFILLER_0_42_271 VPWR VGND VPWR VGND sky130_ef_sc_hd__decap_12
XFILLER_0_30_455 VGND VGND VPWR VPWR sky130_fd_sc_hd__fill_2
XFILLER_0_27_290 VPWR VGND VPWR VGND sky130_ef_sc_hd__decap_12
XFILLER_0_69_113 VGND VGND VPWR VPWR sky130_fd_sc_hd__fill_1
Xmax_cap11 _0515_ VGND VGND VPWR VPWR net390 sky130_fd_sc_hd__buf_1
Xmax_cap44 _0008_ VGND VGND VPWR VPWR net44 sky130_fd_sc_hd__buf_2
XTAP_639 VGND VPWR sky130_fd_sc_hd__tapvpwrvgnd_1
XTAP_628 VGND VPWR sky130_fd_sc_hd__tapvpwrvgnd_1
XTAP_617 VGND VPWR sky130_fd_sc_hd__tapvpwrvgnd_1
XTAP_606 VGND VPWR sky130_fd_sc_hd__tapvpwrvgnd_1
XFILLER_0_33_293 VPWR VGND VPWR VGND sky130_ef_sc_hd__decap_12
X_2150_ net142 _1042_ _1044_ net140 VGND VGND VPWR VPWR _1046_ sky130_fd_sc_hd__nand4_1
XFILLER_0_17_65 VGND VGND VPWR VPWR sky130_fd_sc_hd__fill_1
X_2081_ _0944_ _0947_ VGND VGND VPWR VPWR _0987_ sky130_fd_sc_hd__nand2_4
X_2983_ clknet_leaf_14_clk _0365_ net251 VGND VGND VPWR VPWR tx.baud_cnt\[2\] sky130_fd_sc_hd__dfrtp_1
XFILLER_0_56_363 VGND VGND VPWR VPWR sky130_fd_sc_hd__fill_1
X_1934_ net70 _0902_ VGND VGND VPWR VPWR _0458_ sky130_fd_sc_hd__nor2_1
XFILLER_0_71_399 VGND VGND VPWR VPWR sky130_fd_sc_hd__fill_1
X_1796_ net110 net148 VGND VGND VPWR VPWR _0318_ sky130_fd_sc_hd__nor2_1
X_1865_ tx_fifo.tail\[2\] tx_fifo.tail\[3\] net206 VGND VGND VPWR VPWR _0891_ sky130_fd_sc_hd__nand3_4
XFILLER_0_3_110 VGND VGND VPWR VPWR sky130_fd_sc_hd__fill_2
XFILLER_0_12_411 VGND VGND VPWR VPWR sky130_fd_sc_hd__fill_2
XFILLER_0_12_433 VGND VGND VPWR VPWR sky130_fd_sc_hd__fill_2
XFILLER_0_42_3 VPWR VGND VPWR VGND sky130_ef_sc_hd__decap_12
X_2417_ net149 net90 VGND VGND VPWR VPWR _0303_ sky130_fd_sc_hd__nor2_1
X_2348_ net124 net153 net180 VGND VGND VPWR VPWR _0018_ sky130_fd_sc_hd__nor3_1
XFILLER_0_3_198 VGND VGND VPWR VPWR sky130_fd_sc_hd__fill_2
X_2279_ net10 parity_en _1133_ VGND VGND VPWR VPWR _0104_ sky130_fd_sc_hd__mux2_1
XFILLER_0_70_29 VGND VGND VPWR VPWR sky130_fd_sc_hd__decap_8
Xhold109 tx.baud_cnt\[6\] VGND VGND VPWR VPWR net370 sky130_fd_sc_hd__dlygate4sd3_1
XFILLER_0_65_160 VGND VGND VPWR VPWR sky130_fd_sc_hd__fill_2
XFILLER_0_53_377 VPWR VGND VPWR VGND sky130_ef_sc_hd__decap_12
X_1650_ net210 net113 VGND VGND VPWR VPWR _0188_ sky130_fd_sc_hd__nor2_1
X_1581_ rx_fifo.fifo\[13\]\[2\] net175 net161 rx_fifo.fifo\[9\]\[2\] VGND VGND VPWR
+ VPWR _0786_ sky130_fd_sc_hd__a22oi_1
XTAP_469 VGND VPWR sky130_fd_sc_hd__tapvpwrvgnd_1
X_2202_ regs.rx_fifo_pop net17 rx_fifo.head\[0\] VGND VGND VPWR VPWR _1089_ sky130_fd_sc_hd__a21oi_1
XTAP_458 VGND VPWR sky130_fd_sc_hd__tapvpwrvgnd_1
XTAP_447 VGND VPWR sky130_fd_sc_hd__tapvpwrvgnd_1
XTAP_436 VGND VPWR sky130_fd_sc_hd__tapvpwrvgnd_1
XTAP_425 VGND VPWR sky130_fd_sc_hd__tapvpwrvgnd_1
XTAP_414 VGND VPWR sky130_fd_sc_hd__tapvpwrvgnd_1
XTAP_403 VGND VPWR sky130_fd_sc_hd__tapvpwrvgnd_1
XFILLER_0_28_53 VGND VGND VPWR VPWR sky130_fd_sc_hd__decap_4
XFILLER_0_21_263 VPWR VGND VPWR VGND sky130_ef_sc_hd__decap_12
XFILLER_0_0_113 VPWR VGND VPWR VGND sky130_ef_sc_hd__decap_12
XFILLER_0_44_41 VGND VGND VPWR VPWR sky130_fd_sc_hd__decap_8
X_2133_ tx_fifo.fifo\[14\]\[4\] _1004_ _1009_ tx_fifo.fifo\[15\]\[4\] VGND VGND VPWR
+ VPWR _1030_ sky130_fd_sc_hd__a22oi_1
X_2064_ _0952_ _0972_ VGND VGND VPWR VPWR _0973_ sky130_fd_sc_hd__nand2b_1
X_2966_ clknet_leaf_10_clk _0168_ net244 VGND VGND VPWR VPWR rx.baud_cnt\[1\] sky130_fd_sc_hd__dfrtp_1
XFILLER_0_60_95 VGND VGND VPWR VPWR sky130_fd_sc_hd__decap_4
XFILLER_0_60_62 VGND VGND VPWR VPWR sky130_fd_sc_hd__decap_8
XFILLER_0_44_300 VGND VGND VPWR VPWR sky130_fd_sc_hd__decap_8
X_1917_ net73 _0900_ VGND VGND VPWR VPWR _0443_ sky130_fd_sc_hd__nor2_1
X_2897_ clknet_leaf_30_clk _0075_ net259 VGND VGND VPWR VPWR rx_fifo.count\[1\] sky130_fd_sc_hd__dfrtp_2
X_1779_ net119 net149 VGND VGND VPWR VPWR _0312_ sky130_fd_sc_hd__nor2_1
XFILLER_0_8_85 VGND VGND VPWR VPWR sky130_fd_sc_hd__decap_8
X_1848_ _0879_ net66 VGND VGND VPWR VPWR _0376_ sky130_fd_sc_hd__nor2_1
XFILLER_0_12_241 VGND VGND VPWR VPWR sky130_fd_sc_hd__decap_3
XFILLER_0_50_336 VGND VGND VPWR VPWR sky130_fd_sc_hd__fill_1
X_2820_ clknet_leaf_41_clk _0422_ net37 VGND VGND VPWR VPWR tx_fifo.fifo\[9\]\[1\]
+ sky130_fd_sc_hd__edfxtp_1
X_2751_ clknet_leaf_1_clk _0401_ _0010_ VGND VGND VPWR VPWR tx_fifo.fifo\[12\]\[4\]
+ sky130_fd_sc_hd__edfxtp_1
X_1564_ rx_fifo.fifo\[3\]\[3\] net176 net164 rx_fifo.fifo\[15\]\[3\] net166 rx_fifo.fifo\[2\]\[3\]
+ VGND VGND VPWR VPWR _0770_ sky130_fd_sc_hd__a222oi_1
X_2682_ clknet_leaf_23_clk _0249_ net93 VGND VGND VPWR VPWR rx_fifo.fifo\[9\]\[1\]
+ sky130_fd_sc_hd__edfxtp_1
XFILLER_0_53_163 VGND VGND VPWR VPWR sky130_fd_sc_hd__decap_4
X_1633_ net4 _0713_ _0716_ VGND VGND VPWR VPWR _0158_ sky130_fd_sc_hd__and3_1
X_1702_ net118 net156 VGND VGND VPWR VPWR _0234_ sky130_fd_sc_hd__nor2_1
XFILLER_0_30_65 VGND VGND VPWR VPWR sky130_fd_sc_hd__fill_1
XFILLER_0_5_249 VPWR VGND VPWR VGND sky130_ef_sc_hd__decap_12
X_1495_ rx.baud_cnt\[3\] _0652_ net359 VGND VGND VPWR VPWR _0709_ sky130_fd_sc_hd__a21oi_1
XFILLER_0_39_85 VPWR VGND VPWR VGND sky130_ef_sc_hd__decap_12
XFILLER_0_39_52 VGND VGND VPWR VPWR sky130_fd_sc_hd__fill_1
XTAP_200 VGND VPWR sky130_fd_sc_hd__tapvpwrvgnd_1
XTAP_211 VGND VPWR sky130_fd_sc_hd__tapvpwrvgnd_1
XTAP_222 VGND VPWR sky130_fd_sc_hd__tapvpwrvgnd_1
XTAP_233 VGND VPWR sky130_fd_sc_hd__tapvpwrvgnd_1
XTAP_244 VGND VPWR sky130_fd_sc_hd__tapvpwrvgnd_1
XTAP_255 VGND VPWR sky130_fd_sc_hd__tapvpwrvgnd_1
XTAP_266 VGND VPWR sky130_fd_sc_hd__tapvpwrvgnd_1
XTAP_277 VGND VPWR sky130_fd_sc_hd__tapvpwrvgnd_1
XTAP_288 VGND VPWR sky130_fd_sc_hd__tapvpwrvgnd_1
XTAP_299 VGND VPWR sky130_fd_sc_hd__tapvpwrvgnd_1
X_2116_ tx_fifo.fifo\[10\]\[6\] net195 _1005_ tx_fifo.fifo\[11\]\[6\] VGND VGND VPWR
+ VPWR _1015_ sky130_fd_sc_hd__a22o_1
X_2047_ _0943_ _0958_ _0964_ VGND VGND VPWR VPWR _0965_ sky130_fd_sc_hd__nand3_1
Xfanout59 _1166_ VGND VGND VPWR VPWR net59 sky130_fd_sc_hd__clkbuf_2
X_2949_ clknet_leaf_37_clk _0035_ net255 VGND VGND VPWR VPWR tx_fifo.head\[2\] sky130_fd_sc_hd__dfrtp_1
Xmax_cap181 _1134_ VGND VGND VPWR VPWR net181 sky130_fd_sc_hd__clkbuf_2
XFILLER_0_3_7 VGND VGND VPWR VPWR sky130_fd_sc_hd__fill_1
Xmax_cap192 _1001_ VGND VGND VPWR VPWR net192 sky130_fd_sc_hd__clkbuf_2
XFILLER_0_67_200 VGND VGND VPWR VPWR sky130_fd_sc_hd__decap_8
XFILLER_0_70_409 VGND VGND VPWR VPWR sky130_fd_sc_hd__decap_4
XFILLER_0_63_461 VGND VGND VPWR VPWR sky130_fd_sc_hd__fill_2
X_1280_ rx_fifo.head\[0\] rx_fifo.head\[1\] rx_fifo.head\[3\] net234 VGND VGND VPWR
+ VPWR _0522_ sky130_fd_sc_hd__nor4_2
XFILLER_0_58_200 VPWR VGND VPWR VGND sky130_ef_sc_hd__decap_12
XFILLER_0_73_225 VPWR VGND VPWR VGND sky130_ef_sc_hd__decap_12
XFILLER_0_26_141 VGND VGND VPWR VPWR sky130_fd_sc_hd__decap_6
X_2803_ clknet_leaf_4_clk _0437_ _0003_ VGND VGND VPWR VPWR tx_fifo.fifo\[7\]\[0\]
+ sky130_fd_sc_hd__edfxtp_1
X_2734_ clknet_leaf_43_clk _0488_ net48 VGND VGND VPWR VPWR tx_fifo.fifo\[1\]\[3\]
+ sky130_fd_sc_hd__edfxtp_1
X_1547_ rx_fifo.fifo\[3\]\[4\] net176 net169 rx_fifo.fifo\[6\]\[4\] VGND VGND VPWR
+ VPWR _0754_ sky130_fd_sc_hd__a22o_1
X_2596_ clknet_leaf_22_clk _0317_ net81 VGND VGND VPWR VPWR rx_fifo.fifo\[3\]\[3\]
+ sky130_fd_sc_hd__edfxtp_1
X_1616_ _0714_ _0811_ _0819_ VGND VGND VPWR VPWR _0820_ sky130_fd_sc_hd__o21ai_0
X_2665_ clknet_leaf_26_clk _0276_ net96 VGND VGND VPWR VPWR rx_fifo.fifo\[7\]\[6\]
+ sky130_fd_sc_hd__edfxtp_1
Xfanout227 tx_fifo.head\[2\] VGND VGND VPWR VPWR net227 sky130_fd_sc_hd__clkbuf_4
XFILLER_0_22_380 VGND VGND VPWR VPWR sky130_fd_sc_hd__fill_2
XFILLER_0_5_53 VGND VGND VPWR VPWR sky130_fd_sc_hd__decap_3
Xfanout249 net250 VGND VGND VPWR VPWR net249 sky130_fd_sc_hd__clkbuf_4
XFILLER_0_66_50 VGND VGND VPWR VPWR sky130_fd_sc_hd__fill_1
X_1478_ _0690_ _0693_ _0698_ _0664_ VGND VGND VPWR VPWR _0699_ sky130_fd_sc_hd__nor4bb_2
XFILLER_0_52_409 VGND VGND VPWR VPWR sky130_fd_sc_hd__decap_8
XFILLER_0_9_363 VGND VGND VPWR VPWR sky130_fd_sc_hd__decap_6
XFILLER_0_60_453 VGND VGND VPWR VPWR sky130_fd_sc_hd__decap_8
XFILLER_0_17_141 VGND VGND VPWR VPWR sky130_fd_sc_hd__fill_1
XFILLER_0_20_317 VPWR VGND VPWR VGND sky130_ef_sc_hd__decap_12
XFILLER_0_55_225 VPWR VGND VPWR VGND sky130_ef_sc_hd__decap_12
XFILLER_0_28_428 VGND VGND VPWR VPWR sky130_fd_sc_hd__fill_1
XFILLER_0_11_12 VGND VGND VPWR VPWR sky130_fd_sc_hd__decap_8
X_1401_ net376 _0636_ VGND VGND VPWR VPWR _0639_ sky130_fd_sc_hd__nor2_1
XFILLER_0_51_442 VGND VGND VPWR VPWR sky130_fd_sc_hd__decap_6
X_2450_ rx_fifo.fifo\[1\]\[7\] net168 net167 rx_fifo.fifo\[10\]\[7\] rx_fifo.fifo\[8\]\[7\]
+ net162 VGND VGND VPWR VPWR _1212_ sky130_fd_sc_hd__a222oi_1
X_2381_ _1176_ _1177_ _1178_ VGND VGND VPWR VPWR _1179_ sky130_fd_sc_hd__nand3_1
Xinput5 rst_n VGND VGND VPWR VPWR net5 sky130_fd_sc_hd__clkbuf_2
X_1332_ divisor\[10\] divisor\[8\] divisor\[9\] _0569_ VGND VGND VPWR VPWR _0571_
+ sky130_fd_sc_hd__or4_1
X_1263_ net349 VGND VGND VPWR VPWR _0508_ sky130_fd_sc_hd__inv_1
XFILLER_0_39_9 VGND VGND VPWR VPWR sky130_fd_sc_hd__decap_4
XFILLER_0_52_85 VPWR VGND VPWR VGND sky130_ef_sc_hd__decap_12
XFILLER_0_72_3 VPWR VGND VPWR VGND sky130_ef_sc_hd__decap_12
XFILLER_0_27_461 VGND VGND VPWR VPWR sky130_fd_sc_hd__fill_2
XFILLER_0_6_333 VGND VGND VPWR VPWR sky130_fd_sc_hd__decap_4
XFILLER_0_6_344 VGND VGND VPWR VPWR sky130_fd_sc_hd__fill_1
X_2717_ clknet_leaf_42_clk _0407_ net50 VGND VGND VPWR VPWR tx_fifo.fifo\[11\]\[2\]
+ sky130_fd_sc_hd__edfxtp_1
XFILLER_0_14_155 VGND VGND VPWR VPWR sky130_fd_sc_hd__decap_8
X_2579_ clknet_leaf_25_clk _0333_ net83 VGND VGND VPWR VPWR rx_fifo.fifo\[2\]\[8\]
+ sky130_fd_sc_hd__edfxtp_1
X_2648_ clknet_leaf_23_clk _0203_ net97 VGND VGND VPWR VPWR rx_fifo.fifo\[13\]\[0\]
+ sky130_fd_sc_hd__edfxtp_1
XFILLER_0_77_361 VGND VGND VPWR VPWR sky130_fd_sc_hd__decap_3
XFILLER_0_52_217 VGND VGND VPWR VPWR sky130_fd_sc_hd__decap_8
XFILLER_0_60_261 VGND VGND VPWR VPWR sky130_fd_sc_hd__decap_8
XFILLER_0_60_250 VGND VGND VPWR VPWR sky130_fd_sc_hd__fill_2
XFILLER_0_20_147 VGND VGND VPWR VPWR sky130_fd_sc_hd__fill_1
X_1950_ net72 _0905_ VGND VGND VPWR VPWR _0475_ sky130_fd_sc_hd__nor2_1
X_2502_ rx.bit_cnt\[1\] rx.bit_cnt\[0\] VGND VGND VPWR VPWR _1241_ sky130_fd_sc_hd__nand2_1
X_1881_ net61 _0893_ VGND VGND VPWR VPWR _0397_ sky130_fd_sc_hd__nor2_1
X_1315_ _0552_ _0555_ VGND VGND VPWR VPWR _0556_ sky130_fd_sc_hd__nor2_2
X_2433_ net9 net211 _1134_ VGND VGND VPWR VPWR _0159_ sky130_fd_sc_hd__and3_1
X_2364_ net219 _0900_ net59 VGND VGND VPWR VPWR _0003_ sky130_fd_sc_hd__nor3_1
XFILLER_0_11_169 VGND VGND VPWR VPWR sky130_fd_sc_hd__decap_8
X_2295_ net11 loopback_en _1135_ VGND VGND VPWR VPWR _0117_ sky130_fd_sc_hd__mux2_1
XFILLER_0_59_361 VGND VGND VPWR VPWR sky130_fd_sc_hd__fill_1
XPHY_109 VGND VGND VPWR VPWR sky130_fd_sc_hd__decap_3
XFILLER_0_6_141 VPWR VGND VPWR VGND sky130_ef_sc_hd__decap_12
XFILLER_0_42_283 VGND VGND VPWR VPWR sky130_fd_sc_hd__decap_8
XFILLER_0_42_261 VGND VGND VPWR VPWR sky130_fd_sc_hd__fill_2
XFILLER_0_6_185 VGND VGND VPWR VPWR sky130_fd_sc_hd__decap_8
XFILLER_0_69_169 VGND VGND VPWR VPWR sky130_fd_sc_hd__decap_4
Xmax_cap56 net380 VGND VGND VPWR VPWR net56 sky130_fd_sc_hd__clkbuf_2
Xmax_cap45 _0009_ VGND VGND VPWR VPWR net45 sky130_fd_sc_hd__buf_2
XFILLER_0_33_261 VPWR VGND VPWR VGND sky130_ef_sc_hd__decap_12
XTAP_629 VGND VPWR sky130_fd_sc_hd__tapvpwrvgnd_1
XTAP_618 VGND VPWR sky130_fd_sc_hd__tapvpwrvgnd_1
XTAP_607 VGND VPWR sky130_fd_sc_hd__tapvpwrvgnd_1
XFILLER_0_48_309 VGND VGND VPWR VPWR sky130_fd_sc_hd__fill_2
X_2080_ _0986_ VGND VGND VPWR VPWR _0178_ sky130_fd_sc_hd__inv_1
XFILLER_0_17_55 VGND VGND VPWR VPWR sky130_fd_sc_hd__fill_1
X_2982_ clknet_leaf_13_clk _0364_ net250 VGND VGND VPWR VPWR tx.baud_cnt\[1\] sky130_fd_sc_hd__dfrtp_2
X_1933_ net73 _0902_ VGND VGND VPWR VPWR _0459_ sky130_fd_sc_hd__nor2_1
XFILLER_0_71_345 VGND VGND VPWR VPWR sky130_fd_sc_hd__fill_2
X_1795_ net111 net148 VGND VGND VPWR VPWR _0319_ sky130_fd_sc_hd__nor2_1
X_1864_ net223 tx_fifo.tail\[1\] VGND VGND VPWR VPWR _0890_ sky130_fd_sc_hd__lpflow_isobufsrc_1
XFILLER_0_3_166 VGND VGND VPWR VPWR sky130_fd_sc_hd__fill_2
XFILLER_0_3_100 VGND VGND VPWR VPWR sky130_fd_sc_hd__fill_2
X_2347_ _0839_ net152 _1165_ VGND VGND VPWR VPWR _0019_ sky130_fd_sc_hd__nor3_1
X_2416_ net150 net90 VGND VGND VPWR VPWR _0292_ sky130_fd_sc_hd__nor2_1
X_2278_ net11 parity_type _1133_ VGND VGND VPWR VPWR _0103_ sky130_fd_sc_hd__mux2_1
XFILLER_0_35_3 VGND VGND VPWR VPWR sky130_fd_sc_hd__decap_6
XFILLER_0_74_83 VGND VGND VPWR VPWR sky130_fd_sc_hd__fill_1
XFILLER_0_66_128 VPWR VGND VPWR VGND sky130_ef_sc_hd__decap_12
XFILLER_0_66_117 VGND VGND VPWR VPWR sky130_fd_sc_hd__fill_1
XFILLER_0_7_461 VGND VGND VPWR VPWR sky130_fd_sc_hd__fill_2
XFILLER_0_57_106 VGND VGND VPWR VPWR sky130_fd_sc_hd__fill_1
XFILLER_0_38_342 VPWR VGND VPWR VGND sky130_ef_sc_hd__decap_12
XFILLER_0_53_389 VGND VGND VPWR VPWR sky130_fd_sc_hd__decap_3
X_1580_ rx_fifo.fifo\[10\]\[2\] net167 net164 rx_fifo.fifo\[15\]\[2\] net162 rx_fifo.fifo\[8\]\[2\]
+ VGND VGND VPWR VPWR _0785_ sky130_fd_sc_hd__a222oi_1
XFILLER_0_21_242 VGND VGND VPWR VPWR sky130_fd_sc_hd__fill_1
XFILLER_0_0_103 VGND VGND VPWR VPWR sky130_fd_sc_hd__decap_8
XFILLER_0_0_125 VGND VGND VPWR VPWR sky130_fd_sc_hd__decap_8
X_2201_ net222 _1086_ _1088_ VGND VGND VPWR VPWR _0071_ sky130_fd_sc_hd__nor3_1
XTAP_459 VGND VPWR sky130_fd_sc_hd__tapvpwrvgnd_1
XTAP_448 VGND VPWR sky130_fd_sc_hd__tapvpwrvgnd_1
X_2132_ tx_fifo.fifo\[0\]\[4\] net196 VGND VGND VPWR VPWR _1029_ sky130_fd_sc_hd__nand2_1
XTAP_437 VGND VPWR sky130_fd_sc_hd__tapvpwrvgnd_1
XTAP_426 VGND VPWR sky130_fd_sc_hd__tapvpwrvgnd_1
XTAP_415 VGND VPWR sky130_fd_sc_hd__tapvpwrvgnd_1
XTAP_404 VGND VPWR sky130_fd_sc_hd__tapvpwrvgnd_1
XFILLER_0_21_286 VGND VGND VPWR VPWR sky130_fd_sc_hd__fill_1
XFILLER_0_21_275 VGND VGND VPWR VPWR sky130_fd_sc_hd__decap_4
XFILLER_0_0_169 VPWR VGND VPWR VGND sky130_ef_sc_hd__decap_12
XFILLER_0_48_139 VGND VGND VPWR VPWR sky130_fd_sc_hd__fill_1
XFILLER_0_8_203 VGND VGND VPWR VPWR sky130_fd_sc_hd__fill_1
X_2063_ rx.state\[1\] rx.state\[0\] net232 VGND VGND VPWR VPWR _0972_ sky130_fd_sc_hd__nor3_1
X_2965_ clknet_leaf_10_clk _0161_ net244 VGND VGND VPWR VPWR rx.baud_cnt\[0\] sky130_fd_sc_hd__dfrtp_1
X_1847_ regs.tx_data\[3\] net76 VGND VGND VPWR VPWR _0884_ sky130_fd_sc_hd__nand2_1
X_1916_ tx_fifo.tail\[1\] net223 net200 VGND VGND VPWR VPWR _0900_ sky130_fd_sc_hd__nand3_4
X_2896_ clknet_leaf_30_clk _0076_ net259 VGND VGND VPWR VPWR rx_fifo.count\[0\] sky130_fd_sc_hd__dfrtp_2
X_1778_ _0857_ _0864_ VGND VGND VPWR VPWR _0868_ sky130_fd_sc_hd__nand2_2
XFILLER_0_67_437 VGND VGND VPWR VPWR sky130_fd_sc_hd__decap_8
XFILLER_0_62_186 VGND VGND VPWR VPWR sky130_fd_sc_hd__decap_8
XFILLER_0_62_164 VGND VGND VPWR VPWR sky130_fd_sc_hd__decap_8
XFILLER_0_62_153 VGND VGND VPWR VPWR sky130_fd_sc_hd__decap_4
X_2681_ clknet_leaf_23_clk _0247_ net93 VGND VGND VPWR VPWR rx_fifo.fifo\[9\]\[0\]
+ sky130_fd_sc_hd__edfxtp_1
XFILLER_0_45_109 VGND VGND VPWR VPWR sky130_fd_sc_hd__decap_3
X_2750_ clknet_leaf_7_clk _0400_ net46 VGND VGND VPWR VPWR tx_fifo.fifo\[12\]\[3\]
+ sky130_fd_sc_hd__edfxtp_1
XFILLER_0_38_194 VGND VGND VPWR VPWR sky130_fd_sc_hd__fill_2
XFILLER_0_38_161 VGND VGND VPWR VPWR sky130_fd_sc_hd__decap_4
X_1701_ net120 net156 VGND VGND VPWR VPWR _0235_ sky130_fd_sc_hd__nor2_1
XFILLER_0_26_356 VGND VGND VPWR VPWR sky130_fd_sc_hd__decap_8
XFILLER_0_14_78 VGND VGND VPWR VPWR sky130_fd_sc_hd__decap_6
X_1494_ net74 _0708_ VGND VGND VPWR VPWR _0172_ sky130_fd_sc_hd__nor2_1
X_1632_ rx_fifo.fifo\[0\]\[0\] net215 _0828_ _0833_ VGND VGND VPWR VPWR _0834_ sky130_fd_sc_hd__a211o_1
X_1563_ rx_fifo.fifo\[14\]\[3\] net170 net162 rx_fifo.fifo\[8\]\[3\] VGND VGND VPWR
+ VPWR _0769_ sky130_fd_sc_hd__a22oi_1
XTAP_201 VGND VPWR sky130_fd_sc_hd__tapvpwrvgnd_1
XTAP_212 VGND VPWR sky130_fd_sc_hd__tapvpwrvgnd_1
XTAP_223 VGND VPWR sky130_fd_sc_hd__tapvpwrvgnd_1
XFILLER_0_39_97 VPWR VGND VPWR VGND sky130_ef_sc_hd__decap_12
X_2115_ tx_fifo.fifo\[3\]\[6\] net193 net185 tx_fifo.fifo\[2\]\[6\] VGND VGND VPWR
+ VPWR _1014_ sky130_fd_sc_hd__a22o_1
XTAP_234 VGND VPWR sky130_fd_sc_hd__tapvpwrvgnd_1
XTAP_245 VGND VPWR sky130_fd_sc_hd__tapvpwrvgnd_1
XTAP_256 VGND VPWR sky130_fd_sc_hd__tapvpwrvgnd_1
XTAP_267 VGND VPWR sky130_fd_sc_hd__tapvpwrvgnd_1
XTAP_278 VGND VPWR sky130_fd_sc_hd__tapvpwrvgnd_1
XTAP_289 VGND VPWR sky130_fd_sc_hd__tapvpwrvgnd_1
XFILLER_0_71_51 VGND VGND VPWR VPWR sky130_fd_sc_hd__decap_4
XFILLER_0_49_415 VGND VGND VPWR VPWR sky130_fd_sc_hd__fill_1
X_2046_ _0504_ rx.bit_cnt\[0\] _0505_ _0939_ _0963_ VGND VGND VPWR VPWR _0964_ sky130_fd_sc_hd__a41oi_2
X_2879_ clknet_leaf_12_clk _0090_ net249 VGND VGND VPWR VPWR divisor\[3\] sky130_fd_sc_hd__dfrtp_2
X_2948_ clknet_leaf_37_clk _0036_ net255 VGND VGND VPWR VPWR tx_fifo.head\[1\] sky130_fd_sc_hd__dfrtp_1
Xmax_cap193 net384 VGND VGND VPWR VPWR net193 sky130_fd_sc_hd__clkbuf_2
XTAP_790 VGND VPWR sky130_fd_sc_hd__tapvpwrvgnd_1
XFILLER_0_67_223 VGND VGND VPWR VPWR sky130_fd_sc_hd__fill_1
XFILLER_0_35_164 VGND VGND VPWR VPWR sky130_fd_sc_hd__decap_4
XFILLER_0_35_153 VGND VGND VPWR VPWR sky130_fd_sc_hd__decap_8
XFILLER_0_23_304 VGND VGND VPWR VPWR sky130_fd_sc_hd__fill_1
XFILLER_0_76_29 VPWR VGND VPWR VGND sky130_ef_sc_hd__decap_12
XFILLER_0_31_381 VGND VGND VPWR VPWR sky130_fd_sc_hd__decap_8
XFILLER_0_23_337 VPWR VGND VPWR VGND sky130_ef_sc_hd__decap_12
XFILLER_0_58_212 VPWR VGND VPWR VGND sky130_ef_sc_hd__decap_12
XFILLER_0_18_109 VPWR VGND VPWR VGND sky130_ef_sc_hd__decap_12
XFILLER_0_74_7 VPWR VGND VPWR VGND sky130_ef_sc_hd__decap_12
XFILLER_0_73_237 VGND VGND VPWR VPWR sky130_fd_sc_hd__decap_4
X_2664_ clknet_leaf_17_clk _0275_ net96 VGND VGND VPWR VPWR rx_fifo.fifo\[7\]\[5\]
+ sky130_fd_sc_hd__edfxtp_1
XFILLER_0_54_462 VGND VGND VPWR VPWR sky130_fd_sc_hd__fill_1
XFILLER_0_41_167 VGND VGND VPWR VPWR sky130_fd_sc_hd__fill_1
XFILLER_0_26_197 VGND VGND VPWR VPWR sky130_fd_sc_hd__decap_4
XFILLER_0_26_186 VGND VGND VPWR VPWR sky130_fd_sc_hd__fill_1
X_2733_ clknet_leaf_4_clk _0487_ net48 VGND VGND VPWR VPWR tx_fifo.fifo\[1\]\[2\]
+ sky130_fd_sc_hd__edfxtp_1
X_2802_ clknet_leaf_0_clk _0396_ net40 VGND VGND VPWR VPWR tx_fifo.fifo\[13\]\[7\]
+ sky130_fd_sc_hd__edfxtp_1
X_2595_ clknet_leaf_22_clk _0316_ net81 VGND VGND VPWR VPWR rx_fifo.fifo\[3\]\[2\]
+ sky130_fd_sc_hd__edfxtp_1
X_1546_ rx_fifo.fifo\[7\]\[4\] net172 VGND VGND VPWR VPWR _0753_ sky130_fd_sc_hd__nand2_1
X_1477_ divisor\[12\] rx.baud_cnt\[8\] _0575_ VGND VGND VPWR VPWR _0698_ sky130_fd_sc_hd__xnor3_1
X_1615_ data_bits\[1\] _0734_ _0818_ VGND VGND VPWR VPWR _0819_ sky130_fd_sc_hd__a21oi_1
XFILLER_0_41_178 VGND VGND VPWR VPWR sky130_fd_sc_hd__decap_4
Xfanout228 tx_fifo.head\[1\] VGND VGND VPWR VPWR net228 sky130_fd_sc_hd__clkbuf_4
XFILLER_0_1_275 VGND VGND VPWR VPWR sky130_fd_sc_hd__decap_4
XFILLER_0_64_248 VGND VGND VPWR VPWR sky130_fd_sc_hd__decap_4
XFILLER_0_9_397 VGND VGND VPWR VPWR sky130_fd_sc_hd__fill_1
X_2029_ rx.state\[1\] rx.state\[0\] net232 VGND VGND VPWR VPWR _0947_ sky130_fd_sc_hd__and3b_2
XFILLER_0_32_145 VGND VGND VPWR VPWR sky130_fd_sc_hd__fill_1
XFILLER_0_20_307 VGND VGND VPWR VPWR sky130_fd_sc_hd__fill_1
XFILLER_0_20_329 VGND VGND VPWR VPWR sky130_fd_sc_hd__decap_8
XFILLER_0_63_281 VGND VGND VPWR VPWR sky130_fd_sc_hd__decap_4
XFILLER_0_55_237 VGND VGND VPWR VPWR sky130_fd_sc_hd__decap_4
XFILLER_0_11_57 VGND VGND VPWR VPWR sky130_fd_sc_hd__decap_8
X_1400_ net52 _0638_ VGND VGND VPWR VPWR _0362_ sky130_fd_sc_hd__nor2_1
X_1331_ divisor\[8\] _0569_ VGND VGND VPWR VPWR _0570_ sky130_fd_sc_hd__nor2_1
XFILLER_0_11_318 VGND VGND VPWR VPWR sky130_fd_sc_hd__decap_8
X_2380_ tx_fifo.fifo\[12\]\[7\] net387 net382 tx_fifo.fifo\[2\]\[7\] VGND VGND VPWR
+ VPWR _1178_ sky130_fd_sc_hd__a22oi_1
X_1262_ net335 VGND VGND VPWR VPWR _0507_ sky130_fd_sc_hd__inv_1
XFILLER_0_36_32 VPWR VGND VPWR VGND sky130_ef_sc_hd__decap_12
Xinput6 rx_in VGND VGND VPWR VPWR net6 sky130_fd_sc_hd__clkbuf_2
XFILLER_0_52_97 VGND VGND VPWR VPWR sky130_fd_sc_hd__decap_3
XFILLER_0_65_3 VGND VGND VPWR VPWR sky130_fd_sc_hd__decap_6
X_2647_ clknet_leaf_25_clk _0281_ net98 VGND VGND VPWR VPWR rx_fifo.fifo\[6\]\[10\]
+ sky130_fd_sc_hd__edfxtp_1
XFILLER_0_6_378 VGND VGND VPWR VPWR sky130_fd_sc_hd__fill_1
X_2716_ clknet_leaf_40_clk _0406_ net50 VGND VGND VPWR VPWR tx_fifo.fifo\[11\]\[1\]
+ sky130_fd_sc_hd__edfxtp_1
X_1529_ tx.tx_busy _0737_ VGND VGND VPWR VPWR _0738_ sky130_fd_sc_hd__nor2_1
X_2578_ clknet_leaf_25_clk _0332_ net83 VGND VGND VPWR VPWR rx_fifo.fifo\[2\]\[7\]
+ sky130_fd_sc_hd__edfxtp_1
XFILLER_0_10_373 VGND VGND VPWR VPWR sky130_fd_sc_hd__fill_1
XFILLER_0_77_373 VGND VGND VPWR VPWR sky130_fd_sc_hd__fill_1
XFILLER_0_69_318 VPWR VGND VPWR VGND sky130_ef_sc_hd__decap_12
XFILLER_0_37_248 VPWR VGND VPWR VGND sky130_ef_sc_hd__decap_12
XFILLER_0_33_432 VPWR VGND VPWR VGND sky130_ef_sc_hd__decap_12
XFILLER_0_20_115 VGND VGND VPWR VPWR sky130_fd_sc_hd__decap_8
XFILLER_0_20_126 VGND VGND VPWR VPWR sky130_fd_sc_hd__fill_2
XPHY_90 VGND VGND VPWR VPWR sky130_fd_sc_hd__decap_3
X_1880_ net63 _0893_ VGND VGND VPWR VPWR _0398_ sky130_fd_sc_hd__nor2_1
XFILLER_0_28_248 VGND VGND VPWR VPWR sky130_fd_sc_hd__decap_4
XFILLER_0_28_215 VGND VGND VPWR VPWR sky130_fd_sc_hd__decap_6
XFILLER_0_51_284 VPWR VGND VPWR VGND sky130_ef_sc_hd__decap_12
XFILLER_0_3_337 VPWR VGND VPWR VGND sky130_ef_sc_hd__decap_12
XFILLER_0_3_315 VPWR VGND VPWR VGND sky130_ef_sc_hd__decap_12
X_2501_ _0952_ _0967_ _1240_ VGND VGND VPWR VPWR _0148_ sky130_fd_sc_hd__o21ai_0
X_1314_ _0553_ _0554_ VGND VGND VPWR VPWR _0555_ sky130_fd_sc_hd__nand2_1
X_2294_ net12 net300 _1135_ VGND VGND VPWR VPWR _0116_ sky130_fd_sc_hd__mux2_1
X_2432_ net263 _0992_ _1184_ net75 VGND VGND VPWR VPWR _0138_ sky130_fd_sc_hd__o2bb2ai_1
X_2363_ net219 _0891_ net58 VGND VGND VPWR VPWR _0004_ sky130_fd_sc_hd__nor3_1
XFILLER_0_2_11 VGND VGND VPWR VPWR sky130_fd_sc_hd__fill_1
XFILLER_0_74_365 VPWR VGND VPWR VGND sky130_ef_sc_hd__decap_12
XFILLER_0_27_281 VGND VGND VPWR VPWR sky130_fd_sc_hd__decap_6
XFILLER_0_27_270 VGND VGND VPWR VPWR sky130_fd_sc_hd__decap_8
XFILLER_0_6_153 VGND VGND VPWR VPWR sky130_fd_sc_hd__decap_4
XFILLER_0_15_410 VPWR VGND VPWR VGND sky130_ef_sc_hd__decap_12
XFILLER_0_42_251 VGND VGND VPWR VPWR sky130_fd_sc_hd__fill_1
XFILLER_0_30_424 VGND VGND VPWR VPWR sky130_fd_sc_hd__decap_4
XFILLER_0_6_197 VGND VGND VPWR VPWR sky130_fd_sc_hd__fill_1
XFILLER_0_69_104 VGND VGND VPWR VPWR sky130_fd_sc_hd__decap_8
Xmax_cap46 _0010_ VGND VGND VPWR VPWR net46 sky130_fd_sc_hd__clkbuf_2
Xmax_cap57 _0000_ VGND VGND VPWR VPWR net57 sky130_fd_sc_hd__clkbuf_2
XFILLER_0_65_387 VGND VGND VPWR VPWR sky130_fd_sc_hd__fill_2
XFILLER_0_33_273 VGND VGND VPWR VPWR sky130_fd_sc_hd__decap_6
XFILLER_0_21_413 VGND VGND VPWR VPWR sky130_fd_sc_hd__decap_8
XFILLER_0_0_307 VGND VGND VPWR VPWR sky130_fd_sc_hd__fill_1
XTAP_619 VGND VPWR sky130_fd_sc_hd__tapvpwrvgnd_1
XTAP_608 VGND VPWR sky130_fd_sc_hd__tapvpwrvgnd_1
XFILLER_0_21_457 VGND VGND VPWR VPWR sky130_fd_sc_hd__fill_2
XFILLER_0_17_78 VGND VGND VPWR VPWR sky130_fd_sc_hd__decap_4
X_2981_ clknet_leaf_13_clk _0357_ net249 VGND VGND VPWR VPWR tx.baud_cnt\[0\] sky130_fd_sc_hd__dfrtp_1
XFILLER_0_71_335 VGND VGND VPWR VPWR sky130_fd_sc_hd__fill_1
XFILLER_0_56_376 VGND VGND VPWR VPWR sky130_fd_sc_hd__decap_6
XFILLER_0_56_365 VGND VGND VPWR VPWR sky130_fd_sc_hd__decap_8
X_1863_ net61 _0889_ VGND VGND VPWR VPWR _0381_ sky130_fd_sc_hd__nor2_1
XFILLER_0_33_55 VGND VGND VPWR VPWR sky130_fd_sc_hd__fill_1
XFILLER_0_33_44 VGND VGND VPWR VPWR sky130_fd_sc_hd__fill_2
X_1932_ _0890_ _0899_ VGND VGND VPWR VPWR _0902_ sky130_fd_sc_hd__nand2_4
Xclkbuf_leaf_41_clk clknet_2_0__leaf_clk VGND VGND VPWR VPWR clknet_leaf_41_clk sky130_fd_sc_hd__clkbuf_16
X_2415_ net14 net328 _1132_ VGND VGND VPWR VPWR _0133_ sky130_fd_sc_hd__mux2_1
X_1794_ net113 net148 VGND VGND VPWR VPWR _0320_ sky130_fd_sc_hd__nor2_1
XFILLER_0_24_251 VGND VGND VPWR VPWR sky130_fd_sc_hd__fill_1
X_2346_ _0839_ net158 net180 VGND VGND VPWR VPWR _0020_ sky130_fd_sc_hd__nor3_2
X_2277_ net12 net306 _1133_ VGND VGND VPWR VPWR _0102_ sky130_fd_sc_hd__mux2_1
Xclkbuf_leaf_32_clk clknet_2_1__leaf_clk VGND VGND VPWR VPWR clknet_leaf_32_clk sky130_fd_sc_hd__clkbuf_16
XFILLER_0_30_265 VPWR VGND VPWR VGND sky130_ef_sc_hd__decap_12
XFILLER_0_57_129 VGND VGND VPWR VPWR sky130_fd_sc_hd__fill_1
Xclkbuf_leaf_23_clk clknet_2_3__leaf_clk VGND VGND VPWR VPWR clknet_leaf_23_clk sky130_fd_sc_hd__clkbuf_16
XFILLER_0_53_335 VGND VGND VPWR VPWR sky130_fd_sc_hd__fill_1
XFILLER_0_38_354 VGND VGND VPWR VPWR sky130_fd_sc_hd__decap_8
XFILLER_0_38_321 VPWR VGND VPWR VGND sky130_ef_sc_hd__decap_12
XTAP_405 VGND VPWR sky130_fd_sc_hd__tapvpwrvgnd_1
X_2200_ rx_fifo.head\[1\] _1085_ VGND VGND VPWR VPWR _1088_ sky130_fd_sc_hd__nor2_1
XTAP_449 VGND VPWR sky130_fd_sc_hd__tapvpwrvgnd_1
XTAP_438 VGND VPWR sky130_fd_sc_hd__tapvpwrvgnd_1
XTAP_427 VGND VPWR sky130_fd_sc_hd__tapvpwrvgnd_1
XTAP_416 VGND VPWR sky130_fd_sc_hd__tapvpwrvgnd_1
X_2131_ tx.shift_reg\[6\] _0991_ _0992_ net294 _1028_ VGND VGND VPWR VPWR _0061_ sky130_fd_sc_hd__a221o_1
X_2062_ rx.state\[1\] rx.state\[0\] VGND VGND VPWR VPWR _0971_ sky130_fd_sc_hd__nor2_1
X_2964_ clknet_leaf_30_clk _0178_ net260 VGND VGND VPWR VPWR rx.dr sky130_fd_sc_hd__dfrtp_1
XFILLER_0_71_110 VGND VGND VPWR VPWR sky130_fd_sc_hd__fill_2
Xclkbuf_leaf_14_clk clknet_2_2__leaf_clk VGND VGND VPWR VPWR clknet_leaf_14_clk sky130_fd_sc_hd__clkbuf_16
X_1777_ net101 net150 VGND VGND VPWR VPWR _0291_ sky130_fd_sc_hd__nor2_1
XFILLER_0_29_376 VGND VGND VPWR VPWR sky130_fd_sc_hd__fill_1
X_1846_ _0879_ net68 VGND VGND VPWR VPWR _0377_ sky130_fd_sc_hd__nor2_1
X_1915_ tx_fifo.tail\[2\] tx_fifo.tail\[3\] VGND VGND VPWR VPWR _0899_ sky130_fd_sc_hd__lpflow_isobufsrc_1
XFILLER_0_4_421 VPWR VGND VPWR VGND sky130_ef_sc_hd__decap_12
XFILLER_0_8_32 VGND VGND VPWR VPWR sky130_fd_sc_hd__fill_1
X_2895_ clknet_leaf_36_clk _0131_ net254 VGND VGND VPWR VPWR tx.parity_bit sky130_fd_sc_hd__dfrtp_1
XFILLER_0_69_51 VGND VGND VPWR VPWR sky130_fd_sc_hd__decap_4
XFILLER_0_8_98 VGND VGND VPWR VPWR sky130_fd_sc_hd__decap_8
X_2329_ rx.sample_cnt\[1\] rx.sample_cnt\[0\] _1154_ VGND VGND VPWR VPWR _1159_ sky130_fd_sc_hd__a21oi_1
XFILLER_0_67_449 VPWR VGND VPWR VGND sky130_ef_sc_hd__decap_12
XFILLER_0_47_195 VGND VGND VPWR VPWR sky130_fd_sc_hd__fill_2
XFILLER_0_47_184 VGND VGND VPWR VPWR sky130_fd_sc_hd__decap_3
XFILLER_0_47_151 VGND VGND VPWR VPWR sky130_fd_sc_hd__decap_8
XFILLER_0_35_368 VGND VGND VPWR VPWR sky130_fd_sc_hd__decap_4
X_1631_ net128 net127 _0831_ _0832_ VGND VGND VPWR VPWR _0833_ sky130_fd_sc_hd__nand4_1
XFILLER_0_41_305 VGND VGND VPWR VPWR sky130_fd_sc_hd__decap_3
X_2680_ clknet_leaf_24_clk _0259_ net95 VGND VGND VPWR VPWR rx_fifo.fifo\[8\]\[10\]
+ sky130_fd_sc_hd__edfxtp_1
X_1700_ rx_fifo.tail\[1\] net233 _0859_ VGND VGND VPWR VPWR _0860_ sky130_fd_sc_hd__nand3_2
X_1493_ net378 _0653_ VGND VGND VPWR VPWR _0708_ sky130_fd_sc_hd__xnor2_1
X_1562_ rx_fifo.fifo\[12\]\[3\] net165 VGND VGND VPWR VPWR _0768_ sky130_fd_sc_hd__nand2_1
Xclkbuf_leaf_3_clk clknet_2_0__leaf_clk VGND VGND VPWR VPWR clknet_leaf_3_clk sky130_fd_sc_hd__clkbuf_16
XTAP_202 VGND VPWR sky130_fd_sc_hd__tapvpwrvgnd_1
XTAP_213 VGND VPWR sky130_fd_sc_hd__tapvpwrvgnd_1
XTAP_224 VGND VPWR sky130_fd_sc_hd__tapvpwrvgnd_1
XTAP_235 VGND VPWR sky130_fd_sc_hd__tapvpwrvgnd_1
XTAP_246 VGND VPWR sky130_fd_sc_hd__tapvpwrvgnd_1
XTAP_257 VGND VPWR sky130_fd_sc_hd__tapvpwrvgnd_1
X_2114_ _0995_ _1011_ _1012_ VGND VGND VPWR VPWR _1013_ sky130_fd_sc_hd__nand3_1
XTAP_268 VGND VPWR sky130_fd_sc_hd__tapvpwrvgnd_1
XTAP_279 VGND VPWR sky130_fd_sc_hd__tapvpwrvgnd_1
X_2045_ regs.lcr\[2\] _0947_ _0962_ VGND VGND VPWR VPWR _0963_ sky130_fd_sc_hd__a21oi_1
XFILLER_0_76_224 VPWR VGND VPWR VGND sky130_ef_sc_hd__decap_12
XFILLER_0_64_419 VGND VGND VPWR VPWR sky130_fd_sc_hd__fill_1
XFILLER_0_29_151 VPWR VGND VPWR VGND sky130_ef_sc_hd__decap_12
X_2947_ clknet_leaf_36_clk _0037_ net254 VGND VGND VPWR VPWR tx_fifo.head\[0\] sky130_fd_sc_hd__dfrtp_1
X_2878_ clknet_leaf_12_clk _0091_ net249 VGND VGND VPWR VPWR divisor\[2\] sky130_fd_sc_hd__dfrtp_1
X_1829_ net109 net145 VGND VGND VPWR VPWR _0351_ sky130_fd_sc_hd__nor2_1
XFILLER_0_44_176 VGND VGND VPWR VPWR sky130_fd_sc_hd__decap_3
XFILLER_0_25_390 VGND VGND VPWR VPWR sky130_fd_sc_hd__fill_2
XFILLER_0_4_251 VGND VGND VPWR VPWR sky130_fd_sc_hd__fill_1
XTAP_791 VGND VPWR sky130_fd_sc_hd__tapvpwrvgnd_1
XTAP_780 VGND VPWR sky130_fd_sc_hd__tapvpwrvgnd_1
Xmax_cap194 _1000_ VGND VGND VPWR VPWR net194 sky130_fd_sc_hd__clkbuf_2
XFILLER_0_67_279 VGND VGND VPWR VPWR sky130_fd_sc_hd__fill_1
XFILLER_0_23_349 VGND VGND VPWR VPWR sky130_fd_sc_hd__decap_8
XFILLER_0_73_205 VPWR VGND VPWR VGND sky130_ef_sc_hd__decap_12
XFILLER_0_58_224 VGND VGND VPWR VPWR sky130_fd_sc_hd__decap_4
XFILLER_0_41_66 VGND VGND VPWR VPWR sky130_fd_sc_hd__decap_8
X_2801_ clknet_leaf_43_clk _0395_ _0004_ VGND VGND VPWR VPWR tx_fifo.fifo\[13\]\[6\]
+ sky130_fd_sc_hd__edfxtp_1
X_2594_ clknet_leaf_22_clk _0315_ _0025_ VGND VGND VPWR VPWR rx_fifo.fifo\[3\]\[1\]
+ sky130_fd_sc_hd__edfxtp_1
X_2663_ clknet_leaf_14_clk _0274_ net96 VGND VGND VPWR VPWR rx_fifo.fifo\[7\]\[4\]
+ sky130_fd_sc_hd__edfxtp_1
X_1614_ _0814_ _0817_ VGND VGND VPWR VPWR _0818_ sky130_fd_sc_hd__nand2_1
X_2732_ clknet_leaf_43_clk _0486_ net48 VGND VGND VPWR VPWR tx_fifo.fifo\[1\]\[1\]
+ sky130_fd_sc_hd__edfxtp_1
XFILLER_0_14_305 VGND VGND VPWR VPWR sky130_fd_sc_hd__decap_3
XFILLER_0_66_85 VPWR VGND VPWR VGND sky130_ef_sc_hd__decap_12
X_1476_ rx.baud_cnt\[10\] _0665_ VGND VGND VPWR VPWR _0697_ sky130_fd_sc_hd__xor2_2
X_1545_ _0749_ _0752_ net4 VGND VGND VPWR VPWR net29 sky130_fd_sc_hd__o21a_1
Xfanout218 net219 VGND VGND VPWR VPWR net218 sky130_fd_sc_hd__buf_4
Xfanout229 tx_fifo.head\[1\] VGND VGND VPWR VPWR net229 sky130_fd_sc_hd__clkbuf_4
XFILLER_0_49_202 VGND VGND VPWR VPWR sky130_fd_sc_hd__fill_2
XFILLER_0_10_3 VPWR VGND VPWR VGND sky130_ef_sc_hd__decap_12
X_2028_ rx.state\[0\] _0937_ VGND VGND VPWR VPWR _0946_ sky130_fd_sc_hd__lpflow_isobufsrc_1
XFILLER_0_64_205 VGND VGND VPWR VPWR sky130_fd_sc_hd__decap_6
XFILLER_0_49_279 VGND VGND VPWR VPWR sky130_fd_sc_hd__fill_1
XFILLER_0_45_452 VGND VGND VPWR VPWR sky130_fd_sc_hd__decap_8
XFILLER_0_13_382 VGND VGND VPWR VPWR sky130_fd_sc_hd__decap_8
XFILLER_0_13_393 VPWR VGND VPWR VGND sky130_ef_sc_hd__decap_12
XFILLER_0_28_408 VPWR VGND VPWR VGND sky130_ef_sc_hd__decap_12
X_1330_ divisor\[4\] divisor\[6\] divisor\[7\] divisor\[5\] VGND VGND VPWR VPWR _0569_
+ sky130_fd_sc_hd__or4_4
X_1261_ regs.ier\[3\] VGND VGND VPWR VPWR _0506_ sky130_fd_sc_hd__inv_1
XFILLER_0_31_190 VGND VGND VPWR VPWR sky130_fd_sc_hd__decap_6
XFILLER_0_36_44 VGND VGND VPWR VPWR sky130_fd_sc_hd__decap_4
Xinput7 wdata[0] VGND VGND VPWR VPWR net7 sky130_fd_sc_hd__buf_2
XFILLER_0_46_227 VGND VGND VPWR VPWR sky130_fd_sc_hd__fill_1
XFILLER_0_58_3 VPWR VGND VPWR VGND sky130_ef_sc_hd__decap_12
X_2646_ clknet_leaf_17_clk _0290_ net98 VGND VGND VPWR VPWR rx_fifo.fifo\[6\]\[9\]
+ sky130_fd_sc_hd__edfxtp_1
X_2577_ clknet_leaf_24_clk _0331_ net83 VGND VGND VPWR VPWR rx_fifo.fifo\[2\]\[6\]
+ sky130_fd_sc_hd__edfxtp_1
X_2715_ clknet_leaf_42_clk _0405_ _0014_ VGND VGND VPWR VPWR tx_fifo.fifo\[11\]\[0\]
+ sky130_fd_sc_hd__edfxtp_1
X_1459_ rx.baud_cnt\[4\] _0679_ VGND VGND VPWR VPWR _0680_ sky130_fd_sc_hd__xnor2_1
X_1528_ net34 _0727_ VGND VGND VPWR VPWR _0737_ sky130_fd_sc_hd__nand2_1
XFILLER_0_45_260 VPWR VGND VPWR VGND sky130_ef_sc_hd__decap_12
XFILLER_0_18_441 VGND VGND VPWR VPWR sky130_fd_sc_hd__fill_2
XFILLER_0_68_363 VGND VGND VPWR VPWR sky130_fd_sc_hd__fill_1
XFILLER_0_68_352 VGND VGND VPWR VPWR sky130_fd_sc_hd__fill_1
XPHY_91 VGND VGND VPWR VPWR sky130_fd_sc_hd__decap_3
XPHY_80 VGND VGND VPWR VPWR sky130_fd_sc_hd__decap_3
XFILLER_0_22_24 VGND VGND VPWR VPWR sky130_fd_sc_hd__decap_4
XFILLER_0_51_296 VPWR VGND VPWR VGND sky130_ef_sc_hd__decap_12
X_2431_ net124 net145 net180 VGND VGND VPWR VPWR _0029_ sky130_fd_sc_hd__nor3_2
XFILLER_0_36_293 VGND VGND VPWR VPWR sky130_fd_sc_hd__decap_6
XFILLER_0_3_327 VGND VGND VPWR VPWR sky130_fd_sc_hd__decap_8
X_2500_ net344 _0967_ VGND VGND VPWR VPWR _1240_ sky130_fd_sc_hd__nand2_1
X_1313_ rx_fifo.fifo\[14\]\[9\] net170 _0531_ rx_fifo.fifo\[1\]\[9\] _0536_ rx_fifo.fifo\[5\]\[9\]
+ VGND VGND VPWR VPWR _0554_ sky130_fd_sc_hd__a222oi_1
X_2293_ net13 net299 _1135_ VGND VGND VPWR VPWR _0115_ sky130_fd_sc_hd__mux2_1
XFILLER_0_47_21 VGND VGND VPWR VPWR sky130_fd_sc_hd__decap_6
X_2362_ net219 _0901_ net58 VGND VGND VPWR VPWR _0005_ sky130_fd_sc_hd__nor3_2
XFILLER_0_74_300 VGND VGND VPWR VPWR sky130_fd_sc_hd__decap_8
XFILLER_0_63_42 VPWR VGND VPWR VGND sky130_ef_sc_hd__decap_12
XFILLER_0_59_341 VPWR VGND VPWR VGND sky130_ef_sc_hd__decap_12
XFILLER_0_2_56 VGND VGND VPWR VPWR sky130_fd_sc_hd__fill_1
XFILLER_0_74_377 VPWR VGND VPWR VGND sky130_ef_sc_hd__decap_12
XFILLER_0_15_422 VPWR VGND VPWR VGND sky130_ef_sc_hd__decap_12
X_2629_ clknet_leaf_18_clk _0295_ net99 VGND VGND VPWR VPWR rx_fifo.fifo\[5\]\[3\]
+ sky130_fd_sc_hd__edfxtp_1
XFILLER_0_2_360 VGND VGND VPWR VPWR sky130_fd_sc_hd__decap_4
Xmax_cap47 _0011_ VGND VGND VPWR VPWR net47 sky130_fd_sc_hd__buf_2
XFILLER_0_77_182 VPWR VGND VPWR VGND sky130_ef_sc_hd__decap_12
XFILLER_0_65_355 VPWR VGND VPWR VGND sky130_ef_sc_hd__decap_12
XFILLER_0_65_311 VGND VGND VPWR VPWR sky130_fd_sc_hd__fill_1
XTAP_609 VGND VPWR sky130_fd_sc_hd__tapvpwrvgnd_1
X_2980_ clknet_leaf_7_clk _0167_ net243 VGND VGND VPWR VPWR rx.baud_cnt\[15\] sky130_fd_sc_hd__dfrtp_1
XFILLER_0_8_419 VGND VGND VPWR VPWR sky130_fd_sc_hd__fill_1
XFILLER_0_17_57 VGND VGND VPWR VPWR sky130_fd_sc_hd__decap_8
Xinput10 wdata[3] VGND VGND VPWR VPWR net10 sky130_fd_sc_hd__clkbuf_2
XFILLER_0_71_325 VGND VGND VPWR VPWR sky130_fd_sc_hd__decap_3
X_1793_ net116 net148 VGND VGND VPWR VPWR _0321_ sky130_fd_sc_hd__nor2_1
XFILLER_0_56_333 VPWR VGND VPWR VGND sky130_ef_sc_hd__decap_12
X_1862_ net63 _0889_ VGND VGND VPWR VPWR _0382_ sky130_fd_sc_hd__nor2_1
XFILLER_0_24_263 VGND VGND VPWR VPWR sky130_fd_sc_hd__fill_2
XFILLER_0_3_113 VGND VGND VPWR VPWR sky130_fd_sc_hd__fill_2
X_1931_ net60 _0901_ VGND VGND VPWR VPWR _0445_ sky130_fd_sc_hd__nor2_1
XFILLER_0_12_403 VGND VGND VPWR VPWR sky130_fd_sc_hd__decap_8
X_2414_ net151 net91 VGND VGND VPWR VPWR _0281_ sky130_fd_sc_hd__nor2_1
XFILLER_0_12_425 VGND VGND VPWR VPWR sky130_fd_sc_hd__fill_1
XFILLER_0_74_41 VPWR VGND VPWR VGND sky130_ef_sc_hd__decap_12
X_2345_ _0839_ net151 net180 VGND VGND VPWR VPWR _0021_ sky130_fd_sc_hd__nor3_2
X_2276_ net13 net303 _1133_ VGND VGND VPWR VPWR _0101_ sky130_fd_sc_hd__mux2_1
XFILLER_0_74_141 VPWR VGND VPWR VGND sky130_ef_sc_hd__decap_12
XFILLER_0_62_314 VPWR VGND VPWR VGND sky130_ef_sc_hd__decap_12
XFILLER_0_7_441 VGND VGND VPWR VPWR sky130_fd_sc_hd__decap_6
XFILLER_0_15_241 VGND VGND VPWR VPWR sky130_fd_sc_hd__fill_1
XFILLER_0_15_263 VPWR VGND VPWR VGND sky130_ef_sc_hd__decap_12
XFILLER_0_30_277 VGND VGND VPWR VPWR sky130_fd_sc_hd__decap_6
XFILLER_0_65_152 VGND VGND VPWR VPWR sky130_fd_sc_hd__decap_8
XFILLER_0_38_333 VGND VGND VPWR VPWR sky130_fd_sc_hd__fill_2
XFILLER_0_61_391 VGND VGND VPWR VPWR sky130_fd_sc_hd__fill_1
XTAP_439 VGND VPWR sky130_fd_sc_hd__tapvpwrvgnd_1
XTAP_428 VGND VPWR sky130_fd_sc_hd__tapvpwrvgnd_1
XTAP_417 VGND VPWR sky130_fd_sc_hd__tapvpwrvgnd_1
XTAP_406 VGND VPWR sky130_fd_sc_hd__tapvpwrvgnd_1
XFILLER_0_21_233 VGND VGND VPWR VPWR sky130_fd_sc_hd__fill_2
XFILLER_0_28_89 VPWR VGND VPWR VGND sky130_ef_sc_hd__decap_12
X_2130_ net75 _1027_ VGND VGND VPWR VPWR _1028_ sky130_fd_sc_hd__nor2_1
X_2061_ _0968_ _0969_ VGND VGND VPWR VPWR _0970_ sky130_fd_sc_hd__lpflow_isobufsrc_1
XFILLER_0_56_141 VPWR VGND VPWR VGND sky130_ef_sc_hd__decap_12
XFILLER_0_44_77 VGND VGND VPWR VPWR sky130_fd_sc_hd__decap_6
XFILLER_0_44_66 VGND VGND VPWR VPWR sky130_fd_sc_hd__fill_2
X_1914_ net61 _0898_ VGND VGND VPWR VPWR _0429_ sky130_fd_sc_hd__nor2_1
X_2963_ clknet_leaf_31_clk _0179_ net260 VGND VGND VPWR VPWR rx.framing_err sky130_fd_sc_hd__dfrtp_1
XFILLER_0_71_122 VGND VGND VPWR VPWR sky130_fd_sc_hd__fill_1
X_1776_ net103 net150 VGND VGND VPWR VPWR _0293_ sky130_fd_sc_hd__nor2_1
XFILLER_0_44_336 VGND VGND VPWR VPWR sky130_fd_sc_hd__fill_1
X_1845_ regs.tx_data\[4\] net76 VGND VGND VPWR VPWR _0883_ sky130_fd_sc_hd__nand2_1
XFILLER_0_29_399 VGND VGND VPWR VPWR sky130_fd_sc_hd__fill_2
XFILLER_0_4_433 VPWR VGND VPWR VGND sky130_ef_sc_hd__decap_12
XFILLER_0_12_233 VGND VGND VPWR VPWR sky130_fd_sc_hd__decap_8
X_2894_ clknet_leaf_36_clk _0130_ net253 VGND VGND VPWR VPWR tx.state\[2\] sky130_fd_sc_hd__dfrtp_2
XFILLER_0_40_3 VPWR VGND VPWR VGND sky130_ef_sc_hd__decap_12
X_2328_ rx.sample_cnt\[1\] rx.sample_cnt\[0\] VGND VGND VPWR VPWR _1158_ sky130_fd_sc_hd__nor2_1
X_2259_ net14 net354 net182 VGND VGND VPWR VPWR _0086_ sky130_fd_sc_hd__mux2_1
XFILLER_0_62_133 VGND VGND VPWR VPWR sky130_fd_sc_hd__decap_6
XFILLER_0_62_100 VPWR VGND VPWR VGND sky130_ef_sc_hd__decap_12
XFILLER_0_53_111 VGND VGND VPWR VPWR sky130_fd_sc_hd__fill_1
X_1630_ rx_fifo.fifo\[11\]\[0\] net171 net167 rx_fifo.fifo\[10\]\[0\] rx_fifo.fifo\[5\]\[0\]
+ net163 VGND VGND VPWR VPWR _0832_ sky130_fd_sc_hd__a222oi_1
XFILLER_0_30_57 VGND VGND VPWR VPWR sky130_fd_sc_hd__fill_1
X_1492_ _0654_ net74 _0707_ VGND VGND VPWR VPWR _0173_ sky130_fd_sc_hd__nor3_1
X_1561_ _0764_ _0767_ net4 VGND VGND VPWR VPWR net28 sky130_fd_sc_hd__o21a_1
XTAP_203 VGND VPWR sky130_fd_sc_hd__tapvpwrvgnd_1
XFILLER_0_1_447 VGND VGND VPWR VPWR sky130_fd_sc_hd__fill_1
XTAP_214 VGND VPWR sky130_fd_sc_hd__tapvpwrvgnd_1
XTAP_225 VGND VPWR sky130_fd_sc_hd__tapvpwrvgnd_1
XTAP_236 VGND VPWR sky130_fd_sc_hd__tapvpwrvgnd_1
XTAP_247 VGND VPWR sky130_fd_sc_hd__tapvpwrvgnd_1
XTAP_258 VGND VPWR sky130_fd_sc_hd__tapvpwrvgnd_1
XTAP_269 VGND VPWR sky130_fd_sc_hd__tapvpwrvgnd_1
X_2113_ tx_fifo.fifo\[0\]\[6\] net196 net191 tx_fifo.fifo\[8\]\[6\] _1009_ tx_fifo.fifo\[15\]\[6\]
+ VGND VGND VPWR VPWR _1012_ sky130_fd_sc_hd__a222oi_1
X_2044_ _0939_ _0961_ VGND VGND VPWR VPWR _0962_ sky130_fd_sc_hd__nor2_1
XFILLER_0_76_236 VPWR VGND VPWR VGND sky130_ef_sc_hd__decap_12
XFILLER_0_71_97 VGND VGND VPWR VPWR sky130_fd_sc_hd__fill_1
X_2877_ clknet_leaf_15_clk _0092_ net250 VGND VGND VPWR VPWR divisor\[1\] sky130_fd_sc_hd__dfrtp_2
XFILLER_0_44_166 VGND VGND VPWR VPWR sky130_fd_sc_hd__fill_1
XFILLER_0_29_163 VGND VGND VPWR VPWR sky130_fd_sc_hd__decap_4
X_2946_ clknet_leaf_35_clk _0150_ net254 VGND VGND VPWR VPWR tx_fifo.count\[4\] sky130_fd_sc_hd__dfrtp_4
X_1759_ net116 net151 VGND VGND VPWR VPWR _0288_ sky130_fd_sc_hd__nor2_1
XFILLER_0_44_188 VGND VGND VPWR VPWR sky130_fd_sc_hd__decap_3
X_1828_ net112 net145 VGND VGND VPWR VPWR _0352_ sky130_fd_sc_hd__nor2_1
XFILLER_0_32_317 VGND VGND VPWR VPWR sky130_fd_sc_hd__fill_2
Xmax_cap184 net185 VGND VGND VPWR VPWR net184 sky130_fd_sc_hd__clkbuf_2
XFILLER_0_20_90 VGND VGND VPWR VPWR sky130_fd_sc_hd__fill_1
Xmax_cap195 net385 VGND VGND VPWR VPWR net195 sky130_fd_sc_hd__clkbuf_2
XTAP_792 VGND VPWR sky130_fd_sc_hd__tapvpwrvgnd_1
XTAP_781 VGND VPWR sky130_fd_sc_hd__tapvpwrvgnd_1
XTAP_770 VGND VPWR sky130_fd_sc_hd__tapvpwrvgnd_1
XFILLER_0_67_225 VPWR VGND VPWR VGND sky130_ef_sc_hd__decap_12
XFILLER_0_67_214 VGND VGND VPWR VPWR sky130_fd_sc_hd__fill_2
XFILLER_0_73_217 VGND VGND VPWR VPWR sky130_fd_sc_hd__decap_6
XFILLER_0_39_461 VGND VGND VPWR VPWR sky130_fd_sc_hd__fill_2
X_2800_ clknet_leaf_0_clk _0394_ net40 VGND VGND VPWR VPWR tx_fifo.fifo\[13\]\[5\]
+ sky130_fd_sc_hd__edfxtp_1
X_2731_ clknet_leaf_1_clk _0485_ net48 VGND VGND VPWR VPWR tx_fifo.fifo\[1\]\[0\]
+ sky130_fd_sc_hd__edfxtp_1
X_2662_ clknet_leaf_14_clk _0273_ net96 VGND VGND VPWR VPWR rx_fifo.fifo\[7\]\[3\]
+ sky130_fd_sc_hd__edfxtp_1
X_2593_ clknet_leaf_23_clk _0313_ net81 VGND VGND VPWR VPWR rx_fifo.fifo\[3\]\[0\]
+ sky130_fd_sc_hd__edfxtp_1
X_1613_ regs.oe _0727_ net239 _0816_ net238 net32 VGND VGND VPWR VPWR _0817_ sky130_fd_sc_hd__a222oi_1
X_1544_ _0737_ _0750_ _0751_ VGND VGND VPWR VPWR _0752_ sky130_fd_sc_hd__nand3_1
XFILLER_0_41_147 VPWR VGND VPWR VGND sky130_ef_sc_hd__decap_12
XFILLER_0_66_97 VPWR VGND VPWR VGND sky130_ef_sc_hd__decap_12
X_1475_ _0664_ _0666_ _0667_ _0695_ VGND VGND VPWR VPWR _0696_ sky130_fd_sc_hd__nand4_4
Xfanout219 net220 VGND VGND VPWR VPWR net219 sky130_fd_sc_hd__clkbuf_4
XFILLER_0_5_89 VPWR VGND VPWR VGND sky130_ef_sc_hd__decap_12
XFILLER_0_49_225 VPWR VGND VPWR VGND sky130_ef_sc_hd__decap_12
XFILLER_0_37_409 VGND VGND VPWR VPWR sky130_fd_sc_hd__fill_1
X_2027_ net77 _0942_ _0938_ VGND VGND VPWR VPWR _0945_ sky130_fd_sc_hd__o21a_1
XFILLER_0_72_250 VGND VGND VPWR VPWR sky130_fd_sc_hd__fill_2
XFILLER_0_32_103 VGND VGND VPWR VPWR sky130_fd_sc_hd__fill_2
X_2929_ clknet_leaf_34_clk _0051_ net253 VGND VGND VPWR VPWR rx.state\[1\] sky130_fd_sc_hd__dfrtp_4
XFILLER_0_70_209 VGND VGND VPWR VPWR sky130_fd_sc_hd__fill_1
XFILLER_0_51_401 VGND VGND VPWR VPWR sky130_fd_sc_hd__fill_1
XFILLER_0_23_169 VGND VGND VPWR VPWR sky130_fd_sc_hd__fill_1
Xinput8 wdata[1] VGND VGND VPWR VPWR net8 sky130_fd_sc_hd__clkbuf_4
X_1260_ rx.bit_cnt\[2\] VGND VGND VPWR VPWR _0505_ sky130_fd_sc_hd__inv_1
XFILLER_0_36_89 VGND VGND VPWR VPWR sky130_fd_sc_hd__fill_1
X_2714_ clknet_leaf_2_clk _0388_ net51 VGND VGND VPWR VPWR tx_fifo.fifo\[14\]\[7\]
+ sky130_fd_sc_hd__edfxtp_1
XFILLER_0_77_41 VPWR VGND VPWR VGND sky130_ef_sc_hd__decap_12
X_2645_ clknet_leaf_26_clk _0289_ net98 VGND VGND VPWR VPWR rx_fifo.fifo\[6\]\[8\]
+ sky130_fd_sc_hd__edfxtp_1
X_1527_ _0733_ _0735_ VGND VGND VPWR VPWR _0736_ sky130_fd_sc_hd__nand2_1
X_2576_ clknet_leaf_24_clk _0330_ net83 VGND VGND VPWR VPWR rx_fifo.fifo\[2\]\[5\]
+ sky130_fd_sc_hd__edfxtp_1
XFILLER_0_22_191 VGND VGND VPWR VPWR sky130_fd_sc_hd__fill_1
X_1389_ net79 _0624_ _0625_ net78 VGND VGND VPWR VPWR _0628_ sky130_fd_sc_hd__nand4_4
X_1458_ divisor\[8\] _0569_ VGND VGND VPWR VPWR _0679_ sky130_fd_sc_hd__xnor2_1
XFILLER_0_77_331 VGND VGND VPWR VPWR sky130_fd_sc_hd__decap_4
XFILLER_0_9_185 VPWR VGND VPWR VGND sky130_ef_sc_hd__decap_12
XFILLER_0_45_272 VGND VGND VPWR VPWR sky130_fd_sc_hd__decap_3
XPHY_92 VGND VGND VPWR VPWR sky130_fd_sc_hd__decap_3
XPHY_81 VGND VGND VPWR VPWR sky130_fd_sc_hd__decap_3
XPHY_70 VGND VGND VPWR VPWR sky130_fd_sc_hd__decap_3
XFILLER_0_22_47 VGND VGND VPWR VPWR sky130_fd_sc_hd__fill_1
X_2430_ net221 _0842_ _1201_ VGND VGND VPWR VPWR _0137_ sky130_fd_sc_hd__nor3_1
X_2361_ net218 _0902_ net59 VGND VGND VPWR VPWR _0006_ sky130_fd_sc_hd__nor3_2
X_2292_ net238 net181 VGND VGND VPWR VPWR _1135_ sky130_fd_sc_hd__nand2_4
X_1312_ rx_fifo.fifo\[0\]\[9\] net215 net171 rx_fifo.fifo\[11\]\[9\] rx_fifo.fifo\[10\]\[9\]
+ net167 VGND VGND VPWR VPWR _0553_ sky130_fd_sc_hd__a222oi_1
XFILLER_0_2_24 VGND VGND VPWR VPWR sky130_fd_sc_hd__decap_4
XFILLER_0_74_312 VGND VGND VPWR VPWR sky130_fd_sc_hd__fill_2
XFILLER_0_63_54 VGND VGND VPWR VPWR sky130_fd_sc_hd__fill_2
XFILLER_0_59_353 VGND VGND VPWR VPWR sky130_fd_sc_hd__decap_8
XFILLER_0_19_239 VGND VGND VPWR VPWR sky130_fd_sc_hd__decap_3
XFILLER_0_74_389 VGND VGND VPWR VPWR sky130_fd_sc_hd__decap_4
XFILLER_0_70_3 VPWR VGND VPWR VGND sky130_ef_sc_hd__decap_12
XFILLER_0_42_297 VGND VGND VPWR VPWR sky130_fd_sc_hd__fill_1
XFILLER_0_42_253 VGND VGND VPWR VPWR sky130_fd_sc_hd__decap_8
XFILLER_0_34_209 VGND VGND VPWR VPWR sky130_fd_sc_hd__decap_6
XFILLER_0_15_401 VGND VGND VPWR VPWR sky130_fd_sc_hd__fill_2
XFILLER_0_15_434 VGND VGND VPWR VPWR sky130_fd_sc_hd__decap_4
X_2628_ clknet_leaf_17_clk _0294_ net99 VGND VGND VPWR VPWR rx_fifo.fifo\[5\]\[2\]
+ sky130_fd_sc_hd__edfxtp_1
X_2559_ clknet_leaf_16_clk _0347_ net88 VGND VGND VPWR VPWR rx_fifo.fifo\[0\]\[10\]
+ sky130_fd_sc_hd__edfxtp_1
Xmax_cap48 _0012_ VGND VGND VPWR VPWR net48 sky130_fd_sc_hd__buf_2
Xmax_cap37 _0001_ VGND VGND VPWR VPWR net37 sky130_fd_sc_hd__clkbuf_2
XFILLER_0_77_194 VGND VGND VPWR VPWR sky130_fd_sc_hd__fill_2
XFILLER_0_65_367 VPWR VGND VPWR VGND sky130_ef_sc_hd__decap_12
XFILLER_0_21_404 VGND VGND VPWR VPWR sky130_fd_sc_hd__fill_1
XFILLER_0_0_309 VPWR VGND VPWR VGND sky130_ef_sc_hd__decap_12
XFILLER_0_68_161 VGND VGND VPWR VPWR sky130_fd_sc_hd__decap_8
XFILLER_0_56_345 VPWR VGND VPWR VGND sky130_ef_sc_hd__decap_12
XFILLER_0_33_57 VPWR VGND VPWR VGND sky130_ef_sc_hd__decap_12
X_1930_ net62 _0901_ VGND VGND VPWR VPWR _0446_ sky130_fd_sc_hd__nor2_1
Xinput11 wdata[4] VGND VGND VPWR VPWR net11 sky130_fd_sc_hd__clkbuf_2
XFILLER_0_71_337 VGND VGND VPWR VPWR sky130_fd_sc_hd__decap_8
X_1792_ net118 net148 VGND VGND VPWR VPWR _0322_ sky130_fd_sc_hd__nor2_1
X_1861_ net64 _0889_ VGND VGND VPWR VPWR _0383_ sky130_fd_sc_hd__nor2_1
XFILLER_0_3_169 VGND VGND VPWR VPWR sky130_fd_sc_hd__decap_4
XFILLER_0_58_21 VGND VGND VPWR VPWR sky130_fd_sc_hd__fill_1
X_2413_ net152 net90 VGND VGND VPWR VPWR _0270_ sky130_fd_sc_hd__nor2_1
X_2344_ _0839_ net150 net180 VGND VGND VPWR VPWR _0022_ sky130_fd_sc_hd__nor3_2
XFILLER_0_74_53 VGND VGND VPWR VPWR sky130_fd_sc_hd__decap_6
XFILLER_0_66_109 VGND VGND VPWR VPWR sky130_fd_sc_hd__decap_8
X_2275_ net15 _0734_ VGND VGND VPWR VPWR _1133_ sky130_fd_sc_hd__nand2_4
XFILLER_0_74_197 VPWR VGND VPWR VGND sky130_ef_sc_hd__decap_12
XFILLER_0_74_153 VPWR VGND VPWR VGND sky130_ef_sc_hd__decap_12
XFILLER_0_47_356 VGND VGND VPWR VPWR sky130_fd_sc_hd__decap_6
XFILLER_0_15_275 VGND VGND VPWR VPWR sky130_fd_sc_hd__fill_2
XFILLER_0_38_389 VGND VGND VPWR VPWR sky130_fd_sc_hd__fill_1
XTAP_429 VGND VPWR sky130_fd_sc_hd__tapvpwrvgnd_1
XTAP_418 VGND VPWR sky130_fd_sc_hd__tapvpwrvgnd_1
XTAP_407 VGND VPWR sky130_fd_sc_hd__tapvpwrvgnd_1
XFILLER_0_28_57 VGND VGND VPWR VPWR sky130_fd_sc_hd__fill_1
XFILLER_0_21_223 VGND VGND VPWR VPWR sky130_fd_sc_hd__fill_1
X_2060_ rx.sample_cnt\[3\] net77 _0940_ VGND VGND VPWR VPWR _0969_ sky130_fd_sc_hd__nor3b_1
XFILLER_0_56_153 VPWR VGND VPWR VGND sky130_ef_sc_hd__decap_12
X_1913_ net63 _0898_ VGND VGND VPWR VPWR _0430_ sky130_fd_sc_hd__nor2_1
X_2962_ clknet_leaf_28_clk _0180_ net260 VGND VGND VPWR VPWR rx.parity_err sky130_fd_sc_hd__dfrtp_1
X_2893_ clknet_leaf_36_clk _0077_ net253 VGND VGND VPWR VPWR tx.state\[1\] sky130_fd_sc_hd__dfrtp_4
XFILLER_0_71_178 VGND VGND VPWR VPWR sky130_fd_sc_hd__fill_1
X_1775_ net105 _0867_ VGND VGND VPWR VPWR _0294_ sky130_fd_sc_hd__nor2_1
XFILLER_0_4_445 VPWR VGND VPWR VGND sky130_ef_sc_hd__decap_12
X_1844_ _0879_ net70 VGND VGND VPWR VPWR _0378_ sky130_fd_sc_hd__nor2_1
XFILLER_0_12_267 VGND VGND VPWR VPWR sky130_fd_sc_hd__fill_2
X_2258_ _0823_ _1125_ _1131_ VGND VGND VPWR VPWR _0085_ sky130_fd_sc_hd__o21ai_0
XFILLER_0_33_3 VPWR VGND VPWR VGND sky130_ef_sc_hd__decap_12
X_2327_ net352 _1150_ VGND VGND VPWR VPWR _1157_ sky130_fd_sc_hd__nand2_1
XFILLER_0_39_109 VGND VGND VPWR VPWR sky130_fd_sc_hd__decap_3
X_2189_ rx_fifo.tail\[2\] _0840_ net221 VGND VGND VPWR VPWR _1081_ sky130_fd_sc_hd__a21oi_1
XFILLER_0_62_112 VPWR VGND VPWR VGND sky130_ef_sc_hd__decap_12
XFILLER_0_38_197 VPWR VGND VPWR VGND sky130_ef_sc_hd__decap_12
XFILLER_0_38_131 VGND VGND VPWR VPWR sky130_fd_sc_hd__decap_8
XFILLER_0_53_167 VGND VGND VPWR VPWR sky130_fd_sc_hd__fill_1
X_1560_ _0714_ _0762_ _0766_ VGND VGND VPWR VPWR _0767_ sky130_fd_sc_hd__o21ai_0
X_1491_ rx.baud_cnt\[5\] _0653_ net358 VGND VGND VPWR VPWR _0707_ sky130_fd_sc_hd__a21oi_1
X_2112_ tx_fifo.fifo\[7\]\[6\] _0996_ _1004_ tx_fifo.fifo\[14\]\[6\] VGND VGND VPWR
+ VPWR _1011_ sky130_fd_sc_hd__a22oi_1
XTAP_204 VGND VPWR sky130_fd_sc_hd__tapvpwrvgnd_1
XTAP_215 VGND VPWR sky130_fd_sc_hd__tapvpwrvgnd_1
XTAP_226 VGND VPWR sky130_fd_sc_hd__tapvpwrvgnd_1
XTAP_237 VGND VPWR sky130_fd_sc_hd__tapvpwrvgnd_1
XTAP_248 VGND VPWR sky130_fd_sc_hd__tapvpwrvgnd_1
XTAP_259 VGND VPWR sky130_fd_sc_hd__tapvpwrvgnd_1
XFILLER_0_76_248 VGND VGND VPWR VPWR sky130_fd_sc_hd__decap_4
X_2043_ _0505_ _0959_ _0960_ VGND VGND VPWR VPWR _0961_ sky130_fd_sc_hd__nor3_1
XFILLER_0_72_421 VPWR VGND VPWR VGND sky130_ef_sc_hd__decap_12
XFILLER_0_72_410 VGND VGND VPWR VPWR sky130_fd_sc_hd__decap_8
X_2876_ clknet_leaf_15_clk _0093_ net249 VGND VGND VPWR VPWR divisor\[0\] sky130_fd_sc_hd__dfrtp_2
XFILLER_0_57_440 VGND VGND VPWR VPWR sky130_fd_sc_hd__decap_8
X_1827_ net113 net145 VGND VGND VPWR VPWR _0353_ sky130_fd_sc_hd__nor2_1
XFILLER_0_32_307 VGND VGND VPWR VPWR sky130_fd_sc_hd__fill_1
XFILLER_0_29_175 VGND VGND VPWR VPWR sky130_fd_sc_hd__fill_1
X_2945_ clknet_leaf_35_clk _0038_ net254 VGND VGND VPWR VPWR tx_fifo.count\[3\] sky130_fd_sc_hd__dfrtp_4
X_1689_ net119 net157 VGND VGND VPWR VPWR _0224_ sky130_fd_sc_hd__nor2_1
X_1758_ net117 net151 VGND VGND VPWR VPWR _0289_ sky130_fd_sc_hd__nor2_1
Xmax_cap196 _0997_ VGND VGND VPWR VPWR net196 sky130_fd_sc_hd__clkbuf_2
Xmax_cap185 _1010_ VGND VGND VPWR VPWR net185 sky130_fd_sc_hd__clkbuf_2
XTAP_793 VGND VPWR sky130_fd_sc_hd__tapvpwrvgnd_1
XTAP_782 VGND VPWR sky130_fd_sc_hd__tapvpwrvgnd_1
XTAP_771 VGND VPWR sky130_fd_sc_hd__tapvpwrvgnd_1
XTAP_760 VGND VPWR sky130_fd_sc_hd__tapvpwrvgnd_1
XFILLER_0_75_281 VGND VGND VPWR VPWR sky130_fd_sc_hd__decap_8
XFILLER_0_67_237 VGND VGND VPWR VPWR sky130_fd_sc_hd__decap_3
XFILLER_0_63_443 VGND VGND VPWR VPWR sky130_fd_sc_hd__decap_4
XFILLER_0_50_137 VGND VGND VPWR VPWR sky130_fd_sc_hd__decap_3
XFILLER_0_50_104 VGND VGND VPWR VPWR sky130_fd_sc_hd__fill_1
X_2661_ clknet_leaf_18_clk _0272_ net96 VGND VGND VPWR VPWR rx_fifo.fifo\[7\]\[2\]
+ sky130_fd_sc_hd__edfxtp_1
XFILLER_0_26_112 VGND VGND VPWR VPWR sky130_fd_sc_hd__fill_1
X_2730_ clknet_leaf_39_clk _0500_ _0013_ VGND VGND VPWR VPWR tx_fifo.fifo\[0\]\[7\]
+ sky130_fd_sc_hd__edfxtp_1
X_1612_ net236 _0508_ _0815_ VGND VGND VPWR VPWR _0816_ sky130_fd_sc_hd__o21ai_0
X_1474_ _0671_ _0672_ _0694_ VGND VGND VPWR VPWR _0695_ sky130_fd_sc_hd__nor3_1
X_2592_ clknet_leaf_16_clk _0215_ net82 VGND VGND VPWR VPWR rx_fifo.fifo\[12\]\[10\]
+ sky130_fd_sc_hd__edfxtp_1
X_1543_ net235 regs.dlh\[5\] _0728_ _0734_ regs.lcr\[5\] VGND VGND VPWR VPWR _0751_
+ sky130_fd_sc_hd__a32oi_1
XFILLER_0_41_159 VGND VGND VPWR VPWR sky130_fd_sc_hd__decap_8
XFILLER_0_5_57 VGND VGND VPWR VPWR sky130_fd_sc_hd__decap_8
XFILLER_0_57_281 VPWR VGND VPWR VGND sky130_ef_sc_hd__decap_12
XFILLER_0_49_237 VPWR VGND VPWR VGND sky130_ef_sc_hd__decap_12
X_2026_ _0700_ _0942_ VGND VGND VPWR VPWR _0944_ sky130_fd_sc_hd__nor2_4
XFILLER_0_72_273 VPWR VGND VPWR VGND sky130_ef_sc_hd__decap_12
XFILLER_0_60_402 VGND VGND VPWR VPWR sky130_fd_sc_hd__fill_1
X_2859_ clknet_leaf_5_clk _0107_ net240 VGND VGND VPWR VPWR data_bits\[0\] sky130_fd_sc_hd__dfstp_2
X_2928_ clknet_leaf_34_clk _0052_ net256 VGND VGND VPWR VPWR rx.state\[0\] sky130_fd_sc_hd__dfrtp_4
XFILLER_0_17_145 VPWR VGND VPWR VGND sky130_ef_sc_hd__decap_12
XTAP_590 VGND VPWR sky130_fd_sc_hd__tapvpwrvgnd_1
XFILLER_0_36_421 VPWR VGND VPWR VGND sky130_ef_sc_hd__decap_12
Xinput9 wdata[2] VGND VGND VPWR VPWR net9 sky130_fd_sc_hd__clkbuf_4
XFILLER_0_52_78 VGND VGND VPWR VPWR sky130_fd_sc_hd__decap_6
X_2644_ clknet_leaf_20_clk _0288_ net98 VGND VGND VPWR VPWR rx_fifo.fifo\[6\]\[7\]
+ sky130_fd_sc_hd__edfxtp_1
XFILLER_0_54_273 VGND VGND VPWR VPWR sky130_fd_sc_hd__decap_3
XFILLER_0_54_251 VGND VGND VPWR VPWR sky130_fd_sc_hd__fill_1
XFILLER_0_39_281 VGND VGND VPWR VPWR sky130_fd_sc_hd__decap_6
X_2713_ clknet_leaf_3_clk _0387_ _0015_ VGND VGND VPWR VPWR tx_fifo.fifo\[14\]\[6\]
+ sky130_fd_sc_hd__edfxtp_1
XFILLER_0_6_337 VGND VGND VPWR VPWR sky130_fd_sc_hd__fill_1
XFILLER_0_77_53 VGND VGND VPWR VPWR sky130_fd_sc_hd__decap_3
X_2575_ clknet_leaf_20_clk _0329_ net83 VGND VGND VPWR VPWR rx_fifo.fifo\[2\]\[4\]
+ sky130_fd_sc_hd__edfxtp_1
X_1457_ rx.baud_cnt\[5\] divisor\[9\] _0570_ VGND VGND VPWR VPWR _0678_ sky130_fd_sc_hd__xnor3_1
X_1526_ regs.lcr\[6\] _0734_ VGND VGND VPWR VPWR _0735_ sky130_fd_sc_hd__nand2_1
XFILLER_0_77_321 VGND VGND VPWR VPWR sky130_fd_sc_hd__decap_4
X_1388_ _0583_ _0616_ _0617_ _0626_ VGND VGND VPWR VPWR _0627_ sky130_fd_sc_hd__nor4_1
XFILLER_0_77_365 VGND VGND VPWR VPWR sky130_fd_sc_hd__decap_8
XFILLER_0_33_402 VGND VGND VPWR VPWR sky130_fd_sc_hd__decap_3
X_2009_ tx_fifo.count\[2\] _0922_ VGND VGND VPWR VPWR _0930_ sky130_fd_sc_hd__xnor2_1
XFILLER_0_9_197 VGND VGND VPWR VPWR sky130_fd_sc_hd__decap_8
XPHY_82 VGND VGND VPWR VPWR sky130_fd_sc_hd__decap_3
XPHY_71 VGND VGND VPWR VPWR sky130_fd_sc_hd__decap_3
XPHY_60 VGND VGND VPWR VPWR sky130_fd_sc_hd__decap_3
XFILLER_0_22_15 VGND VGND VPWR VPWR sky130_fd_sc_hd__decap_6
XPHY_93 VGND VGND VPWR VPWR sky130_fd_sc_hd__decap_3
XFILLER_0_36_251 VGND VGND VPWR VPWR sky130_fd_sc_hd__fill_1
X_1311_ net136 _0549_ net135 _0551_ VGND VGND VPWR VPWR _0552_ sky130_fd_sc_hd__nand4_1
X_2291_ net15 net237 VGND VGND VPWR VPWR _1134_ sky130_fd_sc_hd__lpflow_isobufsrc_1
X_2360_ net218 _0879_ net59 VGND VGND VPWR VPWR _0007_ sky130_fd_sc_hd__nor3_2
XFILLER_0_74_346 VPWR VGND VPWR VGND sky130_ef_sc_hd__decap_12
XFILLER_0_59_365 VPWR VGND VPWR VGND sky130_ef_sc_hd__decap_12
X_2627_ clknet_leaf_23_clk _0293_ net99 VGND VGND VPWR VPWR rx_fifo.fifo\[5\]\[1\]
+ sky130_fd_sc_hd__edfxtp_1
XFILLER_0_30_449 VGND VGND VPWR VPWR sky130_fd_sc_hd__fill_1
X_1509_ rx_fifo.fifo\[3\]\[6\] net176 net164 rx_fifo.fifo\[15\]\[6\] net166 rx_fifo.fifo\[2\]\[6\]
+ VGND VGND VPWR VPWR _0718_ sky130_fd_sc_hd__a222oi_1
X_2558_ clknet_leaf_27_clk _0356_ net88 VGND VGND VPWR VPWR rx_fifo.fifo\[0\]\[9\]
+ sky130_fd_sc_hd__edfxtp_1
XFILLER_0_10_151 VPWR VGND VPWR VGND sky130_ef_sc_hd__decap_12
XFILLER_0_10_195 VGND VGND VPWR VPWR sky130_fd_sc_hd__fill_1
X_2489_ net232 _0944_ _0971_ _1235_ VGND VGND VPWR VPWR _1236_ sky130_fd_sc_hd__nand4_1
Xmax_cap38 _0002_ VGND VGND VPWR VPWR net38 sky130_fd_sc_hd__clkbuf_2
Xmax_cap49 _0013_ VGND VGND VPWR VPWR net49 sky130_fd_sc_hd__buf_2
Xclkbuf_leaf_35_clk clknet_2_1__leaf_clk VGND VGND VPWR VPWR clknet_leaf_35_clk sky130_fd_sc_hd__clkbuf_16
XFILLER_0_65_379 VGND VGND VPWR VPWR sky130_fd_sc_hd__decap_8
XFILLER_0_17_15 VPWR VGND VPWR VGND sky130_ef_sc_hd__decap_12
XFILLER_0_56_357 VGND VGND VPWR VPWR sky130_fd_sc_hd__decap_6
Xclkbuf_leaf_26_clk clknet_2_3__leaf_clk VGND VGND VPWR VPWR clknet_leaf_26_clk sky130_fd_sc_hd__clkbuf_16
X_1860_ net67 _0889_ VGND VGND VPWR VPWR _0384_ sky130_fd_sc_hd__nor2_1
XFILLER_0_33_36 VGND VGND VPWR VPWR sky130_fd_sc_hd__decap_8
X_1791_ net120 net148 VGND VGND VPWR VPWR _0323_ sky130_fd_sc_hd__nor2_1
Xinput12 wdata[5] VGND VGND VPWR VPWR net12 sky130_fd_sc_hd__buf_2
X_2274_ net7 net278 _1132_ VGND VGND VPWR VPWR _0100_ sky130_fd_sc_hd__mux2_1
XFILLER_0_58_99 VGND VGND VPWR VPWR sky130_fd_sc_hd__fill_1
XFILLER_0_58_44 VGND VGND VPWR VPWR sky130_fd_sc_hd__decap_4
X_2412_ net153 net90 VGND VGND VPWR VPWR _0259_ sky130_fd_sc_hd__nor2_1
X_2343_ net124 net210 net180 VGND VGND VPWR VPWR _0023_ sky130_fd_sc_hd__nor3_2
Xclkbuf_leaf_17_clk clknet_2_3__leaf_clk VGND VGND VPWR VPWR clknet_leaf_17_clk sky130_fd_sc_hd__clkbuf_16
XFILLER_0_74_165 VPWR VGND VPWR VGND sky130_ef_sc_hd__decap_12
XFILLER_0_62_349 VPWR VGND VPWR VGND sky130_ef_sc_hd__decap_12
XFILLER_0_62_338 VGND VGND VPWR VPWR sky130_fd_sc_hd__decap_8
XFILLER_0_47_324 VGND VGND VPWR VPWR sky130_fd_sc_hd__fill_2
X_1989_ net229 net231 _0912_ VGND VGND VPWR VPWR _0914_ sky130_fd_sc_hd__and3_1
XFILLER_0_30_213 VPWR VGND VPWR VGND sky130_ef_sc_hd__decap_12
XFILLER_0_53_305 VGND VGND VPWR VPWR sky130_fd_sc_hd__fill_2
XFILLER_0_61_393 VPWR VGND VPWR VGND sky130_ef_sc_hd__decap_12
XTAP_419 VGND VPWR sky130_fd_sc_hd__tapvpwrvgnd_1
XTAP_408 VGND VPWR sky130_fd_sc_hd__tapvpwrvgnd_1
XFILLER_0_28_69 VGND VGND VPWR VPWR sky130_fd_sc_hd__decap_6
XFILLER_0_21_279 VGND VGND VPWR VPWR sky130_fd_sc_hd__fill_1
XFILLER_0_76_419 VGND VGND VPWR VPWR sky130_fd_sc_hd__fill_1
XFILLER_0_71_113 VGND VGND VPWR VPWR sky130_fd_sc_hd__fill_1
XFILLER_0_60_78 VGND VGND VPWR VPWR sky130_fd_sc_hd__fill_2
XFILLER_0_56_165 VPWR VGND VPWR VGND sky130_ef_sc_hd__decap_12
XFILLER_0_56_121 VGND VGND VPWR VPWR sky130_fd_sc_hd__fill_1
X_1843_ regs.tx_data\[5\] _0876_ VGND VGND VPWR VPWR _0882_ sky130_fd_sc_hd__nand2_1
XFILLER_0_29_335 VGND VGND VPWR VPWR sky130_fd_sc_hd__fill_1
X_2961_ clknet_leaf_30_clk _0177_ net260 VGND VGND VPWR VPWR rx.break_int sky130_fd_sc_hd__dfrtp_1
X_1912_ net65 _0898_ VGND VGND VPWR VPWR _0431_ sky130_fd_sc_hd__nor2_1
XFILLER_0_4_402 VPWR VGND VPWR VGND sky130_ef_sc_hd__decap_12
X_2892_ clknet_leaf_36_clk _0078_ net253 VGND VGND VPWR VPWR tx.state\[0\] sky130_fd_sc_hd__dfrtp_2
X_1774_ net107 net150 VGND VGND VPWR VPWR _0295_ sky130_fd_sc_hd__nor2_1
Xclkbuf_leaf_6_clk clknet_2_2__leaf_clk VGND VGND VPWR VPWR clknet_leaf_6_clk sky130_fd_sc_hd__clkbuf_16
XFILLER_0_4_457 VGND VGND VPWR VPWR sky130_fd_sc_hd__decap_6
X_2257_ divisor\[8\] net182 VGND VGND VPWR VPWR _1131_ sky130_fd_sc_hd__nand2_1
XFILLER_0_26_3 VPWR VGND VPWR VGND sky130_ef_sc_hd__decap_12
X_2326_ net77 _1156_ _1151_ VGND VGND VPWR VPWR _0127_ sky130_fd_sc_hd__o21ai_0
XFILLER_0_47_165 VGND VGND VPWR VPWR sky130_fd_sc_hd__decap_3
XFILLER_0_47_143 VGND VGND VPWR VPWR sky130_fd_sc_hd__fill_1
X_2188_ tx.shift_reg\[1\] _0991_ _0992_ net308 _1080_ VGND VGND VPWR VPWR _0066_ sky130_fd_sc_hd__a221o_1
XFILLER_0_62_157 VGND VGND VPWR VPWR sky130_fd_sc_hd__fill_1
XFILLER_0_62_124 VGND VGND VPWR VPWR sky130_fd_sc_hd__decap_6
XFILLER_0_58_419 VGND VGND VPWR VPWR sky130_fd_sc_hd__fill_1
XFILLER_0_14_27 VGND VGND VPWR VPWR sky130_fd_sc_hd__fill_1
XFILLER_0_53_113 VGND VGND VPWR VPWR sky130_fd_sc_hd__decap_4
X_1490_ _0655_ net74 _0706_ VGND VGND VPWR VPWR _0174_ sky130_fd_sc_hd__nor3_1
XFILLER_0_53_179 VGND VGND VPWR VPWR sky130_fd_sc_hd__decap_8
XFILLER_0_34_371 VGND VGND VPWR VPWR sky130_fd_sc_hd__decap_8
XTAP_205 VGND VPWR sky130_fd_sc_hd__tapvpwrvgnd_1
XFILLER_0_1_449 VPWR VGND VPWR VGND sky130_ef_sc_hd__decap_12
XFILLER_0_1_405 VPWR VGND VPWR VGND sky130_ef_sc_hd__decap_12
X_2042_ data_bits\[1\] rx.bit_cnt\[1\] VGND VGND VPWR VPWR _0960_ sky130_fd_sc_hd__xor2_1
XTAP_216 VGND VPWR sky130_fd_sc_hd__tapvpwrvgnd_1
XTAP_227 VGND VPWR sky130_fd_sc_hd__tapvpwrvgnd_1
XTAP_238 VGND VPWR sky130_fd_sc_hd__tapvpwrvgnd_1
XTAP_249 VGND VPWR sky130_fd_sc_hd__tapvpwrvgnd_1
Xhold1 rx.parity_err_lat VGND VGND VPWR VPWR net262 sky130_fd_sc_hd__dlygate4sd3_1
X_2111_ net230 net224 net226 net228 VGND VGND VPWR VPWR _1010_ sky130_fd_sc_hd__nor4b_1
XFILLER_0_71_55 VGND VGND VPWR VPWR sky130_fd_sc_hd__fill_1
XFILLER_0_72_433 VPWR VGND VPWR VGND sky130_ef_sc_hd__decap_12
X_2875_ clknet_leaf_6_clk _0133_ net242 VGND VGND VPWR VPWR regs.dlh\[7\] sky130_fd_sc_hd__dfrtp_1
XFILLER_0_44_157 VGND VGND VPWR VPWR sky130_fd_sc_hd__fill_1
X_1826_ net115 net145 VGND VGND VPWR VPWR _0354_ sky130_fd_sc_hd__nor2_1
XFILLER_0_25_393 VGND VGND VPWR VPWR sky130_fd_sc_hd__decap_3
XFILLER_0_4_210 VGND VGND VPWR VPWR sky130_fd_sc_hd__decap_3
X_2944_ clknet_leaf_35_clk _0039_ net253 VGND VGND VPWR VPWR tx_fifo.count\[2\] sky130_fd_sc_hd__dfrtp_4
XTAP_761 VGND VPWR sky130_fd_sc_hd__tapvpwrvgnd_1
XTAP_750 VGND VPWR sky130_fd_sc_hd__tapvpwrvgnd_1
X_1757_ net119 net151 VGND VGND VPWR VPWR _0290_ sky130_fd_sc_hd__nor2_1
X_1688_ rx_fifo.tail\[2\] rx_fifo.tail\[3\] _0857_ VGND VGND VPWR VPWR _0858_ sky130_fd_sc_hd__nand3_2
Xmax_cap197 net387 VGND VGND VPWR VPWR net197 sky130_fd_sc_hd__clkbuf_2
XFILLER_0_20_81 VGND VGND VPWR VPWR sky130_fd_sc_hd__decap_3
XTAP_794 VGND VPWR sky130_fd_sc_hd__tapvpwrvgnd_1
XTAP_783 VGND VPWR sky130_fd_sc_hd__tapvpwrvgnd_1
XTAP_772 VGND VPWR sky130_fd_sc_hd__tapvpwrvgnd_1
X_2309_ _0989_ _1109_ _0628_ VGND VGND VPWR VPWR _1142_ sky130_fd_sc_hd__o21ai_0
XFILLER_0_63_422 VGND VGND VPWR VPWR sky130_fd_sc_hd__fill_1
XFILLER_0_48_430 VGND VGND VPWR VPWR sky130_fd_sc_hd__decap_8
XFILLER_0_35_124 VGND VGND VPWR VPWR sky130_fd_sc_hd__fill_2
XFILLER_0_0_91 VPWR VGND VPWR VGND sky130_ef_sc_hd__decap_12
XFILLER_0_50_149 VGND VGND VPWR VPWR sky130_fd_sc_hd__fill_2
XFILLER_0_31_396 VGND VGND VPWR VPWR sky130_fd_sc_hd__decap_8
XFILLER_0_25_15 VPWR VGND VPWR VGND sky130_ef_sc_hd__decap_12
XFILLER_0_66_293 VGND VGND VPWR VPWR sky130_fd_sc_hd__decap_6
X_2660_ clknet_leaf_14_clk _0271_ net96 VGND VGND VPWR VPWR rx_fifo.fifo\[7\]\[1\]
+ sky130_fd_sc_hd__edfxtp_1
X_1611_ net236 regs.dlh\[1\] VGND VGND VPWR VPWR _0815_ sky130_fd_sc_hd__nand2_1
X_2591_ clknet_leaf_14_clk _0224_ net82 VGND VGND VPWR VPWR rx_fifo.fifo\[12\]\[9\]
+ sky130_fd_sc_hd__edfxtp_1
XFILLER_0_66_33 VGND VGND VPWR VPWR sky130_fd_sc_hd__fill_2
X_1473_ _0674_ _0690_ _0691_ _0693_ VGND VGND VPWR VPWR _0694_ sky130_fd_sc_hd__or4_1
X_1542_ regs.mcr_reg\[5\] _0730_ VGND VGND VPWR VPWR _0750_ sky130_fd_sc_hd__nand2_1
XFILLER_0_22_352 VPWR VGND VPWR VGND sky130_ef_sc_hd__decap_12
XFILLER_0_1_279 VGND VGND VPWR VPWR sky130_fd_sc_hd__fill_1
X_2025_ _0696_ _0942_ VGND VGND VPWR VPWR _0943_ sky130_fd_sc_hd__nor2_1
XFILLER_0_57_293 VGND VGND VPWR VPWR sky130_fd_sc_hd__decap_8
XFILLER_0_49_249 VGND VGND VPWR VPWR sky130_fd_sc_hd__fill_2
XFILLER_0_9_346 VGND VGND VPWR VPWR sky130_fd_sc_hd__fill_1
XFILLER_0_17_113 VGND VGND VPWR VPWR sky130_fd_sc_hd__fill_2
X_2927_ clknet_leaf_31_clk net305 net257 VGND VGND VPWR VPWR regs.rx_data\[7\] sky130_fd_sc_hd__dfrtp_1
XFILLER_0_72_285 VPWR VGND VPWR VGND sky130_ef_sc_hd__decap_12
X_1809_ net105 net147 VGND VGND VPWR VPWR _0327_ sky130_fd_sc_hd__nor2_1
XFILLER_0_60_414 VGND VGND VPWR VPWR sky130_fd_sc_hd__decap_3
X_2858_ clknet_leaf_7_clk _0153_ net243 VGND VGND VPWR VPWR regs.tx_data\[7\] sky130_fd_sc_hd__dfrtp_1
XFILLER_0_32_138 VGND VGND VPWR VPWR sky130_fd_sc_hd__fill_2
X_2789_ clknet_leaf_1_clk _0447_ _0005_ VGND VGND VPWR VPWR tx_fifo.fifo\[6\]\[2\]
+ sky130_fd_sc_hd__edfxtp_1
XTAP_591 VGND VPWR sky130_fd_sc_hd__tapvpwrvgnd_1
XTAP_580 VGND VPWR sky130_fd_sc_hd__tapvpwrvgnd_1
XFILLER_0_63_285 VGND VGND VPWR VPWR sky130_fd_sc_hd__fill_1
XFILLER_0_36_433 VGND VGND VPWR VPWR sky130_fd_sc_hd__decap_4
XFILLER_0_27_444 VGND VGND VPWR VPWR sky130_fd_sc_hd__fill_1
XFILLER_0_6_305 VGND VGND VPWR VPWR sky130_fd_sc_hd__decap_3
XFILLER_0_77_21 VGND VGND VPWR VPWR sky130_fd_sc_hd__decap_6
X_2643_ clknet_leaf_19_clk _0287_ net98 VGND VGND VPWR VPWR rx_fifo.fifo\[6\]\[6\]
+ sky130_fd_sc_hd__edfxtp_1
X_2574_ clknet_leaf_22_clk _0328_ net83 VGND VGND VPWR VPWR rx_fifo.fifo\[2\]\[3\]
+ sky130_fd_sc_hd__edfxtp_1
XFILLER_0_42_425 VGND VGND VPWR VPWR sky130_fd_sc_hd__decap_6
X_2712_ clknet_leaf_2_clk _0386_ net51 VGND VGND VPWR VPWR tx_fifo.fifo\[14\]\[5\]
+ sky130_fd_sc_hd__edfxtp_1
XFILLER_0_14_138 VGND VGND VPWR VPWR sky130_fd_sc_hd__fill_2
X_1387_ _0597_ _0618_ _0619_ VGND VGND VPWR VPWR _0626_ sky130_fd_sc_hd__nand3_1
X_1456_ rx.baud_cnt\[6\] _0571_ _0675_ VGND VGND VPWR VPWR _0677_ sky130_fd_sc_hd__and3b_1
X_1525_ net1 _0731_ VGND VGND VPWR VPWR _0734_ sky130_fd_sc_hd__and2_2
X_2008_ tx_fifo.count\[2\] _0511_ VGND VGND VPWR VPWR _0929_ sky130_fd_sc_hd__xor2_1
XFILLER_0_60_211 VGND VGND VPWR VPWR sky130_fd_sc_hd__fill_1
XFILLER_0_5_393 VPWR VGND VPWR VGND sky130_ef_sc_hd__decap_12
XPHY_94 VGND VGND VPWR VPWR sky130_fd_sc_hd__decap_3
XPHY_83 VGND VGND VPWR VPWR sky130_fd_sc_hd__decap_3
XPHY_72 VGND VGND VPWR VPWR sky130_fd_sc_hd__decap_3
XPHY_61 VGND VGND VPWR VPWR sky130_fd_sc_hd__decap_3
XPHY_50 VGND VGND VPWR VPWR sky130_fd_sc_hd__decap_3
X_1310_ rx_fifo.fifo\[13\]\[9\] net175 net169 rx_fifo.fifo\[6\]\[9\] VGND VGND VPWR
+ VPWR _0551_ sky130_fd_sc_hd__a22oi_1
XFILLER_0_47_57 VGND VGND VPWR VPWR sky130_fd_sc_hd__fill_2
X_2290_ net270 net7 net123 VGND VGND VPWR VPWR _0114_ sky130_fd_sc_hd__mux2_1
XFILLER_0_2_15 VGND VGND VPWR VPWR sky130_fd_sc_hd__decap_6
XFILLER_0_74_358 VGND VGND VPWR VPWR sky130_fd_sc_hd__decap_6
XFILLER_0_59_377 VPWR VGND VPWR VGND sky130_ef_sc_hd__decap_12
XFILLER_0_6_157 VGND VGND VPWR VPWR sky130_fd_sc_hd__fill_1
X_2557_ clknet_leaf_16_clk _0355_ net88 VGND VGND VPWR VPWR rx_fifo.fifo\[0\]\[8\]
+ sky130_fd_sc_hd__edfxtp_1
X_2626_ clknet_leaf_16_clk _0291_ net99 VGND VGND VPWR VPWR rx_fifo.fifo\[5\]\[0\]
+ sky130_fd_sc_hd__edfxtp_1
XFILLER_0_30_428 VGND VGND VPWR VPWR sky130_fd_sc_hd__fill_1
XFILLER_0_10_141 VGND VGND VPWR VPWR sky130_fd_sc_hd__decap_6
XFILLER_0_15_447 VGND VGND VPWR VPWR sky130_fd_sc_hd__fill_1
X_1439_ net122 _0659_ _0661_ VGND VGND VPWR VPWR _0165_ sky130_fd_sc_hd__nor3_1
X_1508_ rx_fifo.fifo\[11\]\[6\] net171 net170 rx_fifo.fifo\[14\]\[6\] net167 rx_fifo.fifo\[10\]\[6\]
+ VGND VGND VPWR VPWR _0717_ sky130_fd_sc_hd__a222oi_1
XFILLER_0_10_163 VPWR VGND VPWR VGND sky130_ef_sc_hd__decap_12
X_2488_ _1229_ _1234_ VGND VGND VPWR VPWR _1235_ sky130_fd_sc_hd__xnor2_1
XFILLER_0_77_141 VPWR VGND VPWR VGND sky130_ef_sc_hd__decap_12
Xmax_cap39 _0003_ VGND VGND VPWR VPWR net39 sky130_fd_sc_hd__buf_2
Xwire216 net390 VGND VGND VPWR VPWR net216 sky130_fd_sc_hd__buf_1
XFILLER_0_33_15 VGND VGND VPWR VPWR sky130_fd_sc_hd__fill_1
XFILLER_0_17_27 VPWR VGND VPWR VGND sky130_ef_sc_hd__decap_12
XFILLER_0_68_141 VGND VGND VPWR VPWR sky130_fd_sc_hd__fill_1
XFILLER_0_64_380 VGND VGND VPWR VPWR sky130_fd_sc_hd__decap_8
X_1790_ rx_fifo.tail\[1\] rx_fifo.tail\[0\] _0869_ VGND VGND VPWR VPWR _0870_ sky130_fd_sc_hd__nand3_2
Xinput13 wdata[6] VGND VGND VPWR VPWR net13 sky130_fd_sc_hd__clkbuf_2
XFILLER_0_58_34 VGND VGND VPWR VPWR sky130_fd_sc_hd__fill_2
X_2411_ net316 net318 net216 _1196_ regs.oe VGND VGND VPWR VPWR _0132_ sky130_fd_sc_hd__a32o_1
XFILLER_0_58_67 VGND VGND VPWR VPWR sky130_fd_sc_hd__decap_3
X_2273_ net8 net287 _1132_ VGND VGND VPWR VPWR _0099_ sky130_fd_sc_hd__mux2_1
X_2342_ net221 net255 VGND VGND VPWR VPWR _1165_ sky130_fd_sc_hd__nand2b_1
XFILLER_0_47_314 VGND VGND VPWR VPWR sky130_fd_sc_hd__decap_4
XFILLER_0_47_303 VGND VGND VPWR VPWR sky130_fd_sc_hd__decap_4
XFILLER_0_74_177 VPWR VGND VPWR VGND sky130_ef_sc_hd__decap_12
XFILLER_0_70_361 VGND VGND VPWR VPWR sky130_fd_sc_hd__decap_3
X_1988_ tx_fifo.count\[4\] _0513_ _0875_ VGND VGND VPWR VPWR _0913_ sky130_fd_sc_hd__o21ai_2
XFILLER_0_15_200 VPWR VGND VPWR VGND sky130_ef_sc_hd__decap_12
X_2609_ clknet_leaf_18_clk _0308_ net80 VGND VGND VPWR VPWR rx_fifo.fifo\[4\]\[5\]
+ sky130_fd_sc_hd__edfxtp_1
XFILLER_0_30_225 VGND VGND VPWR VPWR sky130_fd_sc_hd__decap_6
Xclkbuf_2_2__f_clk clknet_0_clk VGND VGND VPWR VPWR clknet_2_2__leaf_clk sky130_fd_sc_hd__clkbuf_16
XFILLER_0_3_80 VGND VGND VPWR VPWR sky130_fd_sc_hd__decap_4
XFILLER_0_65_111 VGND VGND VPWR VPWR sky130_fd_sc_hd__fill_1
XFILLER_0_61_361 VPWR VGND VPWR VGND sky130_ef_sc_hd__decap_12
XFILLER_0_21_225 VGND VGND VPWR VPWR sky130_fd_sc_hd__decap_8
XTAP_409 VGND VPWR sky130_fd_sc_hd__tapvpwrvgnd_1
XFILLER_0_69_461 VGND VGND VPWR VPWR sky130_fd_sc_hd__fill_2
X_2960_ clknet_leaf_38_clk _0160_ net252 VGND VGND VPWR VPWR regs.tx_start sky130_fd_sc_hd__dfrtp_2
XFILLER_0_71_169 VGND VGND VPWR VPWR sky130_fd_sc_hd__fill_1
X_1773_ net110 net150 VGND VGND VPWR VPWR _0296_ sky130_fd_sc_hd__nor2_1
XFILLER_0_56_177 VGND VGND VPWR VPWR sky130_fd_sc_hd__decap_6
X_2891_ clknet_leaf_8_clk net329 net242 VGND VGND VPWR VPWR divisor\[15\] sky130_fd_sc_hd__dfrtp_4
XFILLER_0_37_391 VGND VGND VPWR VPWR sky130_fd_sc_hd__fill_1
X_1842_ _0879_ net72 VGND VGND VPWR VPWR _0379_ sky130_fd_sc_hd__nor2_1
X_1911_ net67 _0898_ VGND VGND VPWR VPWR _0432_ sky130_fd_sc_hd__nor2_1
XFILLER_0_4_414 VGND VGND VPWR VPWR sky130_fd_sc_hd__decap_6
XFILLER_0_69_55 VGND VGND VPWR VPWR sky130_fd_sc_hd__fill_1
X_2256_ _0815_ _1125_ _1130_ VGND VGND VPWR VPWR _0084_ sky130_fd_sc_hd__o21ai_0
X_2325_ rx.sample_cnt\[2\] _0953_ _1155_ VGND VGND VPWR VPWR _1156_ sky130_fd_sc_hd__a21oi_1
X_2187_ _0988_ _1079_ VGND VGND VPWR VPWR _1080_ sky130_fd_sc_hd__nor2_1
XFILLER_0_19_3 VGND VGND VPWR VPWR sky130_fd_sc_hd__decap_6
XFILLER_0_67_409 VGND VGND VPWR VPWR sky130_fd_sc_hd__fill_1
XFILLER_0_7_274 VGND VGND VPWR VPWR sky130_fd_sc_hd__decap_6
XFILLER_0_53_169 VGND VGND VPWR VPWR sky130_fd_sc_hd__fill_2
XFILLER_0_53_147 VGND VGND VPWR VPWR sky130_fd_sc_hd__decap_8
XFILLER_0_38_177 VGND VGND VPWR VPWR sky130_fd_sc_hd__decap_8
XFILLER_0_34_361 VGND VGND VPWR VPWR sky130_fd_sc_hd__decap_3
XFILLER_0_30_49 VGND VGND VPWR VPWR sky130_fd_sc_hd__decap_8
XFILLER_0_30_27 VGND VGND VPWR VPWR sky130_fd_sc_hd__fill_1
XFILLER_0_19_391 VGND VGND VPWR VPWR sky130_fd_sc_hd__fill_1
XTAP_206 VGND VPWR sky130_fd_sc_hd__tapvpwrvgnd_1
XFILLER_0_1_417 VPWR VGND VPWR VGND sky130_ef_sc_hd__decap_12
XTAP_217 VGND VPWR sky130_fd_sc_hd__tapvpwrvgnd_1
XTAP_228 VGND VPWR sky130_fd_sc_hd__tapvpwrvgnd_1
XTAP_239 VGND VPWR sky130_fd_sc_hd__tapvpwrvgnd_1
X_2110_ net229 net231 net225 net227 VGND VGND VPWR VPWR _1009_ sky130_fd_sc_hd__and4_4
X_2041_ data_bits\[0\] rx.bit_cnt\[0\] VGND VGND VPWR VPWR _0959_ sky130_fd_sc_hd__xor2_1
Xhold2 tx.shift_reg\[7\] VGND VGND VPWR VPWR net263 sky130_fd_sc_hd__dlygate4sd3_1
XFILLER_0_49_409 VGND VGND VPWR VPWR sky130_fd_sc_hd__decap_6
X_2943_ clknet_leaf_35_clk _0040_ net253 VGND VGND VPWR VPWR tx_fifo.count\[1\] sky130_fd_sc_hd__dfrtp_4
XFILLER_0_72_445 VPWR VGND VPWR VGND sky130_ef_sc_hd__decap_12
X_1825_ net117 net145 VGND VGND VPWR VPWR _0355_ sky130_fd_sc_hd__nor2_1
X_2874_ clknet_leaf_6_clk _0094_ net242 VGND VGND VPWR VPWR regs.dlh\[6\] sky130_fd_sc_hd__dfrtp_1
X_1756_ _0853_ net389 VGND VGND VPWR VPWR _0866_ sky130_fd_sc_hd__nand2_2
XFILLER_0_32_309 VGND VGND VPWR VPWR sky130_fd_sc_hd__decap_8
XTAP_795 VGND VPWR sky130_fd_sc_hd__tapvpwrvgnd_1
XTAP_784 VGND VPWR sky130_fd_sc_hd__tapvpwrvgnd_1
XTAP_773 VGND VPWR sky130_fd_sc_hd__tapvpwrvgnd_1
XTAP_762 VGND VPWR sky130_fd_sc_hd__tapvpwrvgnd_1
XTAP_751 VGND VPWR sky130_fd_sc_hd__tapvpwrvgnd_1
XTAP_740 VGND VPWR sky130_fd_sc_hd__tapvpwrvgnd_1
X_1687_ rx_fifo.tail\[1\] net233 VGND VGND VPWR VPWR _0857_ sky130_fd_sc_hd__nor2_2
Xmax_cap198 net388 VGND VGND VPWR VPWR net198 sky130_fd_sc_hd__clkbuf_2
Xmax_cap187 net383 VGND VGND VPWR VPWR net187 sky130_fd_sc_hd__clkbuf_2
X_2308_ net212 _1140_ VGND VGND VPWR VPWR _1141_ sky130_fd_sc_hd__nor2_1
X_2239_ _1112_ _1118_ _1119_ _1120_ _0502_ VGND VGND VPWR VPWR _1121_ sky130_fd_sc_hd__a41oi_1
XFILLER_0_35_169 VPWR VGND VPWR VGND sky130_ef_sc_hd__decap_12
XFILLER_0_0_81 VGND VGND VPWR VPWR sky130_fd_sc_hd__decap_3
XFILLER_0_16_350 VGND VGND VPWR VPWR sky130_fd_sc_hd__fill_2
XFILLER_0_16_361 VGND VGND VPWR VPWR sky130_fd_sc_hd__decap_3
XFILLER_0_25_27 VPWR VGND VPWR VGND sky130_ef_sc_hd__decap_12
XFILLER_0_41_15 VGND VGND VPWR VPWR sky130_fd_sc_hd__fill_1
XFILLER_0_39_453 VGND VGND VPWR VPWR sky130_fd_sc_hd__decap_8
XFILLER_0_54_456 VGND VGND VPWR VPWR sky130_fd_sc_hd__decap_6
X_1610_ net211 _0813_ VGND VGND VPWR VPWR _0814_ sky130_fd_sc_hd__nand2_1
X_2590_ clknet_leaf_16_clk _0223_ net82 VGND VGND VPWR VPWR rx_fifo.fifo\[12\]\[8\]
+ sky130_fd_sc_hd__edfxtp_1
XFILLER_0_26_147 VGND VGND VPWR VPWR sky130_fd_sc_hd__fill_1
XFILLER_0_1_225 VPWR VGND VPWR VGND sky130_ef_sc_hd__decap_12
XFILLER_0_14_309 VPWR VGND VPWR VGND sky130_ef_sc_hd__decap_12
X_1472_ rx.baud_cnt\[7\] _0692_ VGND VGND VPWR VPWR _0693_ sky130_fd_sc_hd__xnor2_1
X_1541_ _0714_ _0748_ VGND VGND VPWR VPWR _0749_ sky130_fd_sc_hd__nor2_1
X_2024_ rx.sample_cnt\[3\] _0940_ VGND VGND VPWR VPWR _0942_ sky130_fd_sc_hd__nand2_2
X_2857_ clknet_leaf_7_clk _0108_ net243 VGND VGND VPWR VPWR regs.tx_data\[6\] sky130_fd_sc_hd__dfrtp_1
X_2926_ clknet_leaf_30_clk net282 net259 VGND VGND VPWR VPWR regs.rx_data\[6\] sky130_fd_sc_hd__dfrtp_1
XFILLER_0_9_314 VGND VGND VPWR VPWR sky130_fd_sc_hd__fill_2
XFILLER_0_17_125 VPWR VGND VPWR VGND sky130_ef_sc_hd__decap_12
XFILLER_0_17_169 VGND VGND VPWR VPWR sky130_fd_sc_hd__decap_6
XFILLER_0_72_297 VGND VGND VPWR VPWR sky130_fd_sc_hd__fill_2
X_1808_ net107 net147 VGND VGND VPWR VPWR _0328_ sky130_fd_sc_hd__nor2_1
X_1739_ net110 net153 VGND VGND VPWR VPWR _0263_ sky130_fd_sc_hd__nor2_1
X_2788_ clknet_leaf_40_clk _0446_ net41 VGND VGND VPWR VPWR tx_fifo.fifo\[6\]\[1\]
+ sky130_fd_sc_hd__edfxtp_1
XTAP_592 VGND VPWR sky130_fd_sc_hd__tapvpwrvgnd_1
XTAP_581 VGND VPWR sky130_fd_sc_hd__tapvpwrvgnd_1
XTAP_570 VGND VPWR sky130_fd_sc_hd__tapvpwrvgnd_1
XFILLER_0_63_231 VGND VGND VPWR VPWR sky130_fd_sc_hd__fill_1
XFILLER_0_31_161 VGND VGND VPWR VPWR sky130_fd_sc_hd__fill_1
XFILLER_0_36_48 VGND VGND VPWR VPWR sky130_fd_sc_hd__fill_1
XFILLER_0_54_253 VPWR VGND VPWR VGND sky130_ef_sc_hd__decap_12
XFILLER_0_54_242 VGND VGND VPWR VPWR sky130_fd_sc_hd__fill_2
XFILLER_0_39_272 VGND VGND VPWR VPWR sky130_fd_sc_hd__decap_8
X_2711_ clknet_leaf_3_clk _0385_ _0015_ VGND VGND VPWR VPWR tx_fifo.fifo\[14\]\[4\]
+ sky130_fd_sc_hd__edfxtp_1
X_2642_ clknet_leaf_19_clk _0286_ net98 VGND VGND VPWR VPWR rx_fifo.fifo\[6\]\[5\]
+ sky130_fd_sc_hd__edfxtp_1
X_2573_ clknet_leaf_22_clk _0327_ net83 VGND VGND VPWR VPWR rx_fifo.fifo\[2\]\[2\]
+ sky130_fd_sc_hd__edfxtp_1
X_1524_ net235 regs.dlh\[6\] _0728_ _0730_ regs.mcr_reg\[6\] VGND VGND VPWR VPWR _0733_
+ sky130_fd_sc_hd__a32oi_1
X_1386_ tx.baud_cnt\[14\] _0580_ VGND VGND VPWR VPWR _0625_ sky130_fd_sc_hd__xnor2_1
X_1455_ _0571_ _0675_ rx.baud_cnt\[6\] VGND VGND VPWR VPWR _0676_ sky130_fd_sc_hd__a21boi_1
XFILLER_0_77_378 VPWR VGND VPWR VGND sky130_ef_sc_hd__decap_12
X_2007_ tx_fifo.count\[2\] _0920_ VGND VGND VPWR VPWR _0928_ sky130_fd_sc_hd__nand2_1
XFILLER_0_9_111 VGND VGND VPWR VPWR sky130_fd_sc_hd__fill_1
XFILLER_0_18_401 VGND VGND VPWR VPWR sky130_fd_sc_hd__fill_1
XFILLER_0_9_166 VGND VGND VPWR VPWR sky130_fd_sc_hd__fill_2
XFILLER_0_9_177 VGND VGND VPWR VPWR sky130_fd_sc_hd__fill_2
X_2909_ clknet_leaf_36_clk net309 net254 VGND VGND VPWR VPWR tx.shift_reg\[0\] sky130_fd_sc_hd__dfrtp_1
XFILLER_0_68_312 VPWR VGND VPWR VGND sky130_ef_sc_hd__decap_12
XPHY_95 VGND VGND VPWR VPWR sky130_fd_sc_hd__decap_3
XPHY_84 VGND VGND VPWR VPWR sky130_fd_sc_hd__decap_3
XPHY_73 VGND VGND VPWR VPWR sky130_fd_sc_hd__decap_3
XFILLER_0_36_253 VGND VGND VPWR VPWR sky130_fd_sc_hd__decap_4
XFILLER_0_36_231 VPWR VGND VPWR VGND sky130_ef_sc_hd__decap_12
XPHY_62 VGND VGND VPWR VPWR sky130_fd_sc_hd__decap_3
XPHY_51 VGND VGND VPWR VPWR sky130_fd_sc_hd__decap_3
XPHY_40 VGND VGND VPWR VPWR sky130_fd_sc_hd__decap_3
XFILLER_0_11_109 VGND VGND VPWR VPWR sky130_fd_sc_hd__decap_3
XFILLER_0_63_57 VPWR VGND VPWR VGND sky130_ef_sc_hd__decap_12
XFILLER_0_27_242 VGND VGND VPWR VPWR sky130_fd_sc_hd__decap_4
XFILLER_0_12_72 VPWR VGND VPWR VGND sky130_ef_sc_hd__decap_12
X_2625_ clknet_leaf_16_clk _0182_ net100 VGND VGND VPWR VPWR rx_fifo.fifo\[15\]\[10\]
+ sky130_fd_sc_hd__edfxtp_1
X_1507_ net237 net178 VGND VGND VPWR VPWR _0716_ sky130_fd_sc_hd__nor2_4
X_2556_ clknet_leaf_27_clk _0354_ net88 VGND VGND VPWR VPWR rx_fifo.fifo\[0\]\[7\]
+ sky130_fd_sc_hd__edfxtp_1
XFILLER_0_10_131 VGND VGND VPWR VPWR sky130_fd_sc_hd__decap_8
XFILLER_0_10_175 VPWR VGND VPWR VGND sky130_ef_sc_hd__decap_12
X_2487_ _1232_ _1233_ VGND VGND VPWR VPWR _1234_ sky130_fd_sc_hd__xnor2_1
X_1369_ tx.baud_cnt\[2\] _0565_ _0603_ VGND VGND VPWR VPWR _0608_ sky130_fd_sc_hd__nand3_1
X_1438_ rx.baud_cnt\[12\] _0658_ net341 VGND VGND VPWR VPWR _0661_ sky130_fd_sc_hd__a21oi_1
XFILLER_0_49_3 VGND VGND VPWR VPWR sky130_fd_sc_hd__fill_2
XFILLER_0_10_197 VPWR VGND VPWR VGND sky130_ef_sc_hd__decap_12
XFILLER_0_77_197 VPWR VGND VPWR VGND sky130_ef_sc_hd__decap_12
XFILLER_0_77_153 VPWR VGND VPWR VGND sky130_ef_sc_hd__decap_12
XFILLER_0_77_120 VGND VGND VPWR VPWR sky130_fd_sc_hd__decap_8
XFILLER_0_33_234 VGND VGND VPWR VPWR sky130_fd_sc_hd__decap_3
XFILLER_0_68_131 VGND VGND VPWR VPWR sky130_fd_sc_hd__fill_2
XFILLER_0_56_304 VGND VGND VPWR VPWR sky130_fd_sc_hd__fill_1
XFILLER_0_33_49 VGND VGND VPWR VPWR sky130_fd_sc_hd__decap_6
XFILLER_0_17_39 VPWR VGND VPWR VGND sky130_ef_sc_hd__decap_12
Xinput14 wdata[7] VGND VGND VPWR VPWR net14 sky130_fd_sc_hd__clkbuf_2
XFILLER_0_68_197 VPWR VGND VPWR VGND sky130_ef_sc_hd__decap_12
X_2410_ net4 _0727_ VGND VGND VPWR VPWR _1196_ sky130_fd_sc_hd__nand2_1
X_2341_ net221 net149 _1164_ VGND VGND VPWR VPWR _0024_ sky130_fd_sc_hd__nor3_2
XFILLER_0_20_462 VGND VGND VPWR VPWR sky130_fd_sc_hd__fill_1
X_2272_ net9 net286 _1132_ VGND VGND VPWR VPWR _0098_ sky130_fd_sc_hd__mux2_1
XFILLER_0_35_9 VGND VGND VPWR VPWR sky130_fd_sc_hd__fill_1
XFILLER_0_74_189 VGND VGND VPWR VPWR sky130_fd_sc_hd__decap_4
X_1987_ tx.tx_busy net34 net121 VGND VGND VPWR VPWR _0912_ sky130_fd_sc_hd__nor3_4
XFILLER_0_15_212 VPWR VGND VPWR VGND sky130_ef_sc_hd__decap_12
X_2608_ clknet_leaf_18_clk _0307_ net80 VGND VGND VPWR VPWR rx_fifo.fifo\[4\]\[4\]
+ sky130_fd_sc_hd__edfxtp_1
X_2539_ clknet_leaf_20_clk _0227_ _0030_ VGND VGND VPWR VPWR rx_fifo.fifo\[11\]\[1\]
+ sky130_fd_sc_hd__edfxtp_1
XFILLER_0_38_304 VGND VGND VPWR VPWR sky130_fd_sc_hd__decap_4
XFILLER_0_3_92 VGND VGND VPWR VPWR sky130_fd_sc_hd__decap_8
XFILLER_0_65_178 VGND VGND VPWR VPWR sky130_fd_sc_hd__fill_1
XFILLER_0_61_373 VPWR VGND VPWR VGND sky130_ef_sc_hd__decap_12
XFILLER_0_44_15 VPWR VGND VPWR VGND sky130_ef_sc_hd__decap_12
Xfanout180 _1165_ VGND VGND VPWR VPWR net180 sky130_fd_sc_hd__clkbuf_4
XFILLER_0_28_27 VGND VGND VPWR VPWR sky130_fd_sc_hd__fill_1
XFILLER_0_60_14 VGND VGND VPWR VPWR sky130_fd_sc_hd__decap_4
X_2890_ clknet_leaf_6_clk _0079_ net242 VGND VGND VPWR VPWR divisor\[14\] sky130_fd_sc_hd__dfrtp_4
X_1910_ net69 _0898_ VGND VGND VPWR VPWR _0433_ sky130_fd_sc_hd__nor2_1
X_1772_ net111 net150 VGND VGND VPWR VPWR _0297_ sky130_fd_sc_hd__nor2_1
X_1841_ regs.tx_data\[6\] net76 VGND VGND VPWR VPWR _0881_ sky130_fd_sc_hd__nand2_1
X_2324_ _0940_ _1152_ _1154_ VGND VGND VPWR VPWR _1155_ sky130_fd_sc_hd__nor3_1
XFILLER_0_20_281 VGND VGND VPWR VPWR sky130_fd_sc_hd__fill_1
X_2255_ divisor\[9\] net182 VGND VGND VPWR VPWR _1130_ sky130_fd_sc_hd__nand2_1
X_2186_ _1074_ _1078_ VGND VGND VPWR VPWR _1079_ sky130_fd_sc_hd__nor2_1
XFILLER_0_35_329 VGND VGND VPWR VPWR sky130_fd_sc_hd__fill_1
XFILLER_0_66_421 VPWR VGND VPWR VGND sky130_ef_sc_hd__decap_12
XFILLER_0_14_29 VPWR VGND VPWR VGND sky130_ef_sc_hd__decap_12
XFILLER_0_26_307 VGND VGND VPWR VPWR sky130_fd_sc_hd__fill_1
XTAP_207 VGND VPWR sky130_fd_sc_hd__tapvpwrvgnd_1
XFILLER_0_1_429 VPWR VGND VPWR VGND sky130_ef_sc_hd__decap_12
XTAP_218 VGND VPWR sky130_fd_sc_hd__tapvpwrvgnd_1
XTAP_229 VGND VPWR sky130_fd_sc_hd__tapvpwrvgnd_1
Xhold3 _0060_ VGND VGND VPWR VPWR net264 sky130_fd_sc_hd__dlygate4sd3_1
X_2040_ rx.bit_cnt\[1\] rx.bit_cnt\[0\] VGND VGND VPWR VPWR _0958_ sky130_fd_sc_hd__xor2_1
XFILLER_0_72_457 VGND VGND VPWR VPWR sky130_fd_sc_hd__decap_6
XFILLER_0_71_57 VGND VGND VPWR VPWR sky130_fd_sc_hd__decap_8
XFILLER_0_69_281 VPWR VGND VPWR VGND sky130_ef_sc_hd__decap_12
XFILLER_0_57_410 VPWR VGND VPWR VGND sky130_ef_sc_hd__decap_12
X_2873_ clknet_leaf_6_clk _0095_ net241 VGND VGND VPWR VPWR regs.dlh\[5\] sky130_fd_sc_hd__dfrtp_1
XFILLER_0_29_167 VGND VGND VPWR VPWR sky130_fd_sc_hd__fill_1
X_2942_ clknet_leaf_35_clk _0041_ net254 VGND VGND VPWR VPWR tx_fifo.count\[0\] sky130_fd_sc_hd__dfrtp_4
XFILLER_0_17_318 VPWR VGND VPWR VGND sky130_ef_sc_hd__decap_12
Xmax_cap122 _0585_ VGND VGND VPWR VPWR net122 sky130_fd_sc_hd__clkbuf_2
X_1755_ net102 net152 VGND VGND VPWR VPWR _0269_ sky130_fd_sc_hd__nor2_1
X_1686_ net101 net158 VGND VGND VPWR VPWR _0203_ sky130_fd_sc_hd__nor2_1
Xmax_cap177 _0518_ VGND VGND VPWR VPWR net177 sky130_fd_sc_hd__buf_1
XFILLER_0_40_321 VGND VGND VPWR VPWR sky130_fd_sc_hd__fill_2
X_1824_ net120 net145 VGND VGND VPWR VPWR _0356_ sky130_fd_sc_hd__nor2_1
XTAP_785 VGND VPWR sky130_fd_sc_hd__tapvpwrvgnd_1
XTAP_774 VGND VPWR sky130_fd_sc_hd__tapvpwrvgnd_1
XTAP_763 VGND VPWR sky130_fd_sc_hd__tapvpwrvgnd_1
XTAP_752 VGND VPWR sky130_fd_sc_hd__tapvpwrvgnd_1
XTAP_741 VGND VPWR sky130_fd_sc_hd__tapvpwrvgnd_1
XTAP_730 VGND VPWR sky130_fd_sc_hd__tapvpwrvgnd_1
XFILLER_0_31_3 VGND VGND VPWR VPWR sky130_fd_sc_hd__decap_6
XFILLER_0_29_92 VPWR VGND VPWR VGND sky130_ef_sc_hd__decap_12
Xmax_cap199 _0968_ VGND VGND VPWR VPWR net199 sky130_fd_sc_hd__clkbuf_1
Xmax_cap188 _1006_ VGND VGND VPWR VPWR net188 sky130_fd_sc_hd__clkbuf_2
X_2238_ _0628_ _1113_ VGND VGND VPWR VPWR _1120_ sky130_fd_sc_hd__nand2_1
X_2307_ tx.state\[2\] _0614_ VGND VGND VPWR VPWR _1140_ sky130_fd_sc_hd__lpflow_isobufsrc_1
X_2169_ tx_fifo.fifo\[11\]\[1\] _1005_ _1009_ tx_fifo.fifo\[15\]\[1\] _1062_ VGND
+ VGND VPWR VPWR _1063_ sky130_fd_sc_hd__a221oi_1
XFILLER_0_43_181 VGND VGND VPWR VPWR sky130_fd_sc_hd__decap_3
XFILLER_0_9_91 VGND VGND VPWR VPWR sky130_fd_sc_hd__decap_4
XFILLER_0_25_39 VGND VGND VPWR VPWR sky130_fd_sc_hd__decap_4
XFILLER_0_26_137 VGND VGND VPWR VPWR sky130_fd_sc_hd__decap_3
X_1540_ divisor\[5\] net237 _0716_ _0747_ VGND VGND VPWR VPWR _0748_ sky130_fd_sc_hd__a22oi_1
XFILLER_0_1_237 VGND VGND VPWR VPWR sky130_fd_sc_hd__decap_8
X_1471_ divisor\[11\] net160 VGND VGND VPWR VPWR _0692_ sky130_fd_sc_hd__xor2_1
X_2023_ rx.sample_cnt\[3\] _0940_ VGND VGND VPWR VPWR _0941_ sky130_fd_sc_hd__and2_0
XFILLER_0_15_72 VPWR VGND VPWR VGND sky130_ef_sc_hd__decap_12
X_1807_ net109 net147 VGND VGND VPWR VPWR _0329_ sky130_fd_sc_hd__nor2_1
XFILLER_0_57_251 VGND VGND VPWR VPWR sky130_fd_sc_hd__decap_8
XFILLER_0_45_413 VPWR VGND VPWR VGND sky130_ef_sc_hd__decap_12
X_2856_ clknet_leaf_38_clk _0109_ net240 VGND VGND VPWR VPWR regs.tx_data\[5\] sky130_fd_sc_hd__dfrtp_1
XFILLER_0_31_82 VGND VGND VPWR VPWR sky130_fd_sc_hd__fill_2
XFILLER_0_17_137 VGND VGND VPWR VPWR sky130_fd_sc_hd__decap_4
X_2925_ clknet_leaf_31_clk net315 net258 VGND VGND VPWR VPWR regs.rx_data\[5\] sky130_fd_sc_hd__dfrtp_1
X_1669_ net111 net159 VGND VGND VPWR VPWR _0198_ sky130_fd_sc_hd__nor2_1
XFILLER_0_40_195 VGND VGND VPWR VPWR sky130_fd_sc_hd__fill_1
X_1738_ net112 net153 VGND VGND VPWR VPWR _0264_ sky130_fd_sc_hd__nor2_1
XFILLER_0_0_281 VGND VGND VPWR VPWR sky130_fd_sc_hd__fill_2
X_2787_ clknet_leaf_42_clk _0445_ _0005_ VGND VGND VPWR VPWR tx_fifo.fifo\[6\]\[0\]
+ sky130_fd_sc_hd__edfxtp_1
XTAP_593 VGND VPWR sky130_fd_sc_hd__tapvpwrvgnd_1
XTAP_582 VGND VPWR sky130_fd_sc_hd__tapvpwrvgnd_1
XTAP_571 VGND VPWR sky130_fd_sc_hd__tapvpwrvgnd_1
XTAP_560 VGND VPWR sky130_fd_sc_hd__tapvpwrvgnd_1
XFILLER_0_48_295 VGND VGND VPWR VPWR sky130_fd_sc_hd__fill_1
XFILLER_0_51_449 VPWR VGND VPWR VGND sky130_ef_sc_hd__decap_12
XFILLER_0_51_405 VGND VGND VPWR VPWR sky130_fd_sc_hd__fill_1
XFILLER_0_36_27 VGND VGND VPWR VPWR sky130_fd_sc_hd__fill_1
XFILLER_0_31_184 VGND VGND VPWR VPWR sky130_fd_sc_hd__decap_3
XFILLER_0_52_26 VGND VGND VPWR VPWR sky130_fd_sc_hd__fill_2
XFILLER_0_54_265 VGND VGND VPWR VPWR sky130_fd_sc_hd__decap_8
X_2710_ clknet_leaf_2_clk _0384_ net51 VGND VGND VPWR VPWR tx_fifo.fifo\[14\]\[3\]
+ sky130_fd_sc_hd__edfxtp_1
XFILLER_0_14_129 VGND VGND VPWR VPWR sky130_fd_sc_hd__fill_2
X_2641_ clknet_leaf_20_clk _0285_ net98 VGND VGND VPWR VPWR rx_fifo.fifo\[6\]\[4\]
+ sky130_fd_sc_hd__edfxtp_1
X_2572_ clknet_leaf_22_clk _0326_ net83 VGND VGND VPWR VPWR rx_fifo.fifo\[2\]\[1\]
+ sky130_fd_sc_hd__edfxtp_1
X_1454_ divisor\[8\] divisor\[9\] _0569_ divisor\[10\] VGND VGND VPWR VPWR _0675_
+ sky130_fd_sc_hd__o31ai_1
X_1523_ _0731_ net1 VGND VGND VPWR VPWR _0732_ sky130_fd_sc_hd__lpflow_isobufsrc_1
XFILLER_0_22_195 VGND VGND VPWR VPWR sky130_fd_sc_hd__fill_1
X_1385_ _0620_ _0623_ VGND VGND VPWR VPWR _0624_ sky130_fd_sc_hd__nor2_1
XFILLER_0_77_335 VGND VGND VPWR VPWR sky130_fd_sc_hd__fill_1
XFILLER_0_26_82 VGND VGND VPWR VPWR sky130_fd_sc_hd__fill_2
X_2006_ _0921_ _0925_ _0926_ _0927_ net220 VGND VGND VPWR VPWR _0038_ sky130_fd_sc_hd__a41oi_1
XFILLER_0_9_156 VGND VGND VPWR VPWR sky130_fd_sc_hd__fill_1
XFILLER_0_60_246 VGND VGND VPWR VPWR sky130_fd_sc_hd__fill_1
X_2839_ clknet_leaf_15_clk _0123_ net248 VGND VGND VPWR VPWR regs.ier\[1\] sky130_fd_sc_hd__dfrtp_1
XFILLER_0_33_449 VPWR VGND VPWR VGND sky130_ef_sc_hd__decap_12
X_2908_ clknet_leaf_28_clk _0137_ net256 VGND VGND VPWR VPWR rx_fifo.tail\[3\] sky130_fd_sc_hd__dfrtp_4
XFILLER_0_13_184 VPWR VGND VPWR VGND sky130_ef_sc_hd__decap_12
Xwire1 _0000_ VGND VGND VPWR VPWR net380 sky130_fd_sc_hd__buf_1
XFILLER_0_68_324 VGND VGND VPWR VPWR sky130_fd_sc_hd__decap_4
Xclkbuf_leaf_38_clk clknet_2_1__leaf_clk VGND VGND VPWR VPWR clknet_leaf_38_clk sky130_fd_sc_hd__clkbuf_16
XTAP_390 VGND VPWR sky130_fd_sc_hd__tapvpwrvgnd_1
XPHY_30 VGND VGND VPWR VPWR sky130_fd_sc_hd__decap_3
XPHY_96 VGND VGND VPWR VPWR sky130_fd_sc_hd__decap_3
XPHY_85 VGND VGND VPWR VPWR sky130_fd_sc_hd__decap_3
XPHY_74 VGND VGND VPWR VPWR sky130_fd_sc_hd__decap_3
XFILLER_0_36_243 VGND VGND VPWR VPWR sky130_fd_sc_hd__decap_8
XFILLER_0_36_210 VGND VGND VPWR VPWR sky130_fd_sc_hd__fill_1
XPHY_63 VGND VGND VPWR VPWR sky130_fd_sc_hd__decap_3
XPHY_52 VGND VGND VPWR VPWR sky130_fd_sc_hd__decap_3
XFILLER_0_22_29 VPWR VGND VPWR VGND sky130_ef_sc_hd__decap_12
XPHY_41 VGND VGND VPWR VPWR sky130_fd_sc_hd__decap_3
XFILLER_0_51_279 VGND VGND VPWR VPWR sky130_fd_sc_hd__fill_1
XFILLER_0_63_69 VPWR VGND VPWR VGND sky130_ef_sc_hd__decap_12
XFILLER_0_59_335 VGND VGND VPWR VPWR sky130_fd_sc_hd__fill_1
Xclkbuf_leaf_29_clk clknet_2_1__leaf_clk VGND VGND VPWR VPWR clknet_leaf_29_clk sky130_fd_sc_hd__clkbuf_16
X_2624_ clknet_leaf_14_clk _0191_ net100 VGND VGND VPWR VPWR rx_fifo.fifo\[15\]\[9\]
+ sky130_fd_sc_hd__edfxtp_1
XFILLER_0_27_221 VGND VGND VPWR VPWR sky130_fd_sc_hd__decap_3
XFILLER_0_2_321 VPWR VGND VPWR VGND sky130_ef_sc_hd__decap_12
XFILLER_0_15_449 VGND VGND VPWR VPWR sky130_fd_sc_hd__decap_6
X_1437_ net292 _0659_ _0660_ VGND VGND VPWR VPWR _0166_ sky130_fd_sc_hd__a21oi_1
X_1506_ divisor\[6\] net235 VGND VGND VPWR VPWR _0715_ sky130_fd_sc_hd__nand2_1
X_2555_ clknet_leaf_28_clk _0353_ net88 VGND VGND VPWR VPWR rx_fifo.fifo\[0\]\[6\]
+ sky130_fd_sc_hd__edfxtp_1
XFILLER_0_2_365 VPWR VGND VPWR VGND sky130_ef_sc_hd__decap_12
XFILLER_0_10_187 VGND VGND VPWR VPWR sky130_fd_sc_hd__decap_8
X_2486_ parity_type _0952_ VGND VGND VPWR VPWR _1233_ sky130_fd_sc_hd__xnor2_1
X_1368_ _0501_ tx.baud_cnt\[0\] _0605_ VGND VGND VPWR VPWR _0607_ sky130_fd_sc_hd__o21ai_0
X_1299_ rx_fifo.fifo\[14\]\[10\] net170 net169 rx_fifo.fifo\[6\]\[10\] net161 rx_fifo.fifo\[9\]\[10\]
+ VGND VGND VPWR VPWR _0541_ sky130_fd_sc_hd__a222oi_1
XFILLER_0_77_165 VGND VGND VPWR VPWR sky130_fd_sc_hd__decap_3
XFILLER_0_18_243 VGND VGND VPWR VPWR sky130_fd_sc_hd__decap_3
XFILLER_0_73_393 VGND VGND VPWR VPWR sky130_fd_sc_hd__decap_4
XFILLER_0_33_279 VGND VGND VPWR VPWR sky130_fd_sc_hd__fill_1
Xinput15 wr_en VGND VGND VPWR VPWR net15 sky130_fd_sc_hd__clkbuf_4
XFILLER_0_3_118 VPWR VGND VPWR VGND sky130_ef_sc_hd__decap_12
X_2271_ net10 net274 _1132_ VGND VGND VPWR VPWR _0097_ sky130_fd_sc_hd__mux2_1
X_2340_ net221 net148 _1164_ VGND VGND VPWR VPWR _0025_ sky130_fd_sc_hd__nor3_2
X_1986_ net271 net76 _0911_ VGND VGND VPWR VPWR _0034_ sky130_fd_sc_hd__o21a_1
X_2607_ clknet_leaf_18_clk _0306_ net80 VGND VGND VPWR VPWR rx_fifo.fifo\[4\]\[3\]
+ sky130_fd_sc_hd__edfxtp_1
XFILLER_0_70_341 VPWR VGND VPWR VGND sky130_ef_sc_hd__decap_12
Xclkbuf_leaf_9_clk clknet_2_2__leaf_clk VGND VGND VPWR VPWR clknet_leaf_9_clk sky130_fd_sc_hd__clkbuf_16
X_2538_ clknet_leaf_16_clk _0225_ net89 VGND VGND VPWR VPWR rx_fifo.fifo\[11\]\[0\]
+ sky130_fd_sc_hd__edfxtp_1
X_2469_ _0953_ _1150_ net366 VGND VGND VPWR VPWR _1224_ sky130_fd_sc_hd__o21ai_0
XFILLER_0_65_113 VGND VGND VPWR VPWR sky130_fd_sc_hd__decap_4
XFILLER_0_61_330 VGND VGND VPWR VPWR sky130_fd_sc_hd__decap_6
XFILLER_0_61_385 VGND VGND VPWR VPWR sky130_fd_sc_hd__decap_6
XFILLER_0_21_238 VGND VGND VPWR VPWR sky130_fd_sc_hd__decap_4
Xfanout170 _0529_ VGND VGND VPWR VPWR net170 sky130_fd_sc_hd__clkbuf_4
XFILLER_0_44_27 VGND VGND VPWR VPWR sky130_fd_sc_hd__fill_1
XFILLER_0_69_441 VGND VGND VPWR VPWR sky130_fd_sc_hd__decap_6
XFILLER_0_29_305 VPWR VGND VPWR VGND sky130_ef_sc_hd__decap_12
X_1840_ _0877_ _0879_ VGND VGND VPWR VPWR _0880_ sky130_fd_sc_hd__nor2_1
XFILLER_0_52_396 VGND VGND VPWR VPWR sky130_fd_sc_hd__decap_8
XFILLER_0_52_363 VGND VGND VPWR VPWR sky130_fd_sc_hd__fill_1
X_1771_ net114 net150 VGND VGND VPWR VPWR _0298_ sky130_fd_sc_hd__nor2_1
XFILLER_0_37_393 VGND VGND VPWR VPWR sky130_fd_sc_hd__fill_1
XFILLER_0_8_27 VGND VGND VPWR VPWR sky130_fd_sc_hd__fill_1
XFILLER_0_12_205 VGND VGND VPWR VPWR sky130_fd_sc_hd__fill_1
X_2254_ _0799_ _1125_ _1129_ VGND VGND VPWR VPWR _0083_ sky130_fd_sc_hd__o21ai_0
X_2323_ net199 _1153_ VGND VGND VPWR VPWR _1154_ sky130_fd_sc_hd__nor2_1
XFILLER_0_47_113 VGND VGND VPWR VPWR sky130_fd_sc_hd__decap_6
X_2185_ _1070_ _1075_ _1076_ net137 VGND VGND VPWR VPWR _1078_ sky130_fd_sc_hd__nand4_1
X_1969_ net66 _0907_ VGND VGND VPWR VPWR _0488_ sky130_fd_sc_hd__nor2_1
XFILLER_0_7_210 VPWR VGND VPWR VGND sky130_ef_sc_hd__decap_12
XFILLER_0_70_193 VGND VGND VPWR VPWR sky130_fd_sc_hd__decap_3
XFILLER_0_66_433 VGND VGND VPWR VPWR sky130_fd_sc_hd__fill_2
XFILLER_0_34_330 VGND VGND VPWR VPWR sky130_fd_sc_hd__decap_8
XFILLER_0_30_29 VPWR VGND VPWR VGND sky130_ef_sc_hd__decap_12
Xhold4 regs.tx_data\[3\] VGND VGND VPWR VPWR net265 sky130_fd_sc_hd__dlygate4sd3_1
XTAP_208 VGND VPWR sky130_fd_sc_hd__tapvpwrvgnd_1
XTAP_219 VGND VPWR sky130_fd_sc_hd__tapvpwrvgnd_1
XFILLER_0_71_69 VGND VGND VPWR VPWR sky130_fd_sc_hd__fill_1
XFILLER_0_69_293 VGND VGND VPWR VPWR sky130_fd_sc_hd__fill_1
XFILLER_0_57_422 VPWR VGND VPWR VGND sky130_ef_sc_hd__decap_12
X_2872_ clknet_leaf_6_clk _0096_ net247 VGND VGND VPWR VPWR regs.dlh\[4\] sky130_fd_sc_hd__dfrtp_1
XFILLER_0_44_149 VGND VGND VPWR VPWR sky130_fd_sc_hd__decap_8
X_1823_ _0857_ _0869_ VGND VGND VPWR VPWR _0873_ sky130_fd_sc_hd__nand2_2
XFILLER_0_29_179 VGND VGND VPWR VPWR sky130_fd_sc_hd__decap_8
XFILLER_0_29_113 VGND VGND VPWR VPWR sky130_fd_sc_hd__decap_6
XFILLER_0_17_308 VGND VGND VPWR VPWR sky130_fd_sc_hd__fill_1
X_2941_ clknet_leaf_31_clk _0149_ net257 VGND VGND VPWR VPWR rx.bit_cnt\[2\] sky130_fd_sc_hd__dfrtp_1
X_1685_ net103 net158 VGND VGND VPWR VPWR _0205_ sky130_fd_sc_hd__nor2_1
X_1754_ net104 net152 VGND VGND VPWR VPWR _0271_ sky130_fd_sc_hd__nor2_1
Xmax_cap134 _0577_ VGND VGND VPWR VPWR net134 sky130_fd_sc_hd__clkbuf_1
Xmax_cap123 _0160_ VGND VGND VPWR VPWR net123 sky130_fd_sc_hd__buf_2
Xmax_cap178 _0516_ VGND VGND VPWR VPWR net178 sky130_fd_sc_hd__clkbuf_2
XTAP_786 VGND VPWR sky130_fd_sc_hd__tapvpwrvgnd_1
XTAP_775 VGND VPWR sky130_fd_sc_hd__tapvpwrvgnd_1
XTAP_764 VGND VPWR sky130_fd_sc_hd__tapvpwrvgnd_1
XTAP_753 VGND VPWR sky130_fd_sc_hd__tapvpwrvgnd_1
XTAP_742 VGND VPWR sky130_fd_sc_hd__tapvpwrvgnd_1
XTAP_731 VGND VPWR sky130_fd_sc_hd__tapvpwrvgnd_1
XTAP_720 VGND VPWR sky130_fd_sc_hd__tapvpwrvgnd_1
X_2306_ _0509_ _1136_ _1139_ VGND VGND VPWR VPWR _0124_ sky130_fd_sc_hd__a21oi_1
X_2237_ _0628_ _0989_ VGND VGND VPWR VPWR _1119_ sky130_fd_sc_hd__nand2_1
XFILLER_0_67_219 VGND VGND VPWR VPWR sky130_fd_sc_hd__decap_4
XFILLER_0_67_208 VGND VGND VPWR VPWR sky130_fd_sc_hd__decap_3
X_2168_ tx_fifo.fifo\[10\]\[1\] net195 _1001_ tx_fifo.fifo\[9\]\[1\] VGND VGND VPWR
+ VPWR _1062_ sky130_fd_sc_hd__a22o_1
X_2099_ net231 net227 net225 net229 VGND VGND VPWR VPWR _0998_ sky130_fd_sc_hd__nor4bb_1
XFILLER_0_63_447 VGND VGND VPWR VPWR sky130_fd_sc_hd__fill_1
XFILLER_0_16_385 VGND VGND VPWR VPWR sky130_fd_sc_hd__decap_3
XFILLER_0_16_396 VGND VGND VPWR VPWR sky130_fd_sc_hd__decap_6
XFILLER_0_39_411 VGND VGND VPWR VPWR sky130_fd_sc_hd__fill_2
XFILLER_0_66_241 VGND VGND VPWR VPWR sky130_fd_sc_hd__decap_4
X_1470_ _0576_ _0673_ rx.baud_cnt\[8\] VGND VGND VPWR VPWR _0691_ sky130_fd_sc_hd__a21oi_1
XFILLER_0_41_108 VGND VGND VPWR VPWR sky130_fd_sc_hd__decap_4
X_2022_ rx.sample_cnt\[2\] rx.sample_cnt\[1\] rx.sample_cnt\[0\] VGND VGND VPWR VPWR
+ _0940_ sky130_fd_sc_hd__and3_1
XFILLER_0_15_51 VGND VGND VPWR VPWR sky130_fd_sc_hd__fill_1
XFILLER_0_15_84 VGND VGND VPWR VPWR sky130_fd_sc_hd__fill_1
XFILLER_0_60_406 VGND VGND VPWR VPWR sky130_fd_sc_hd__decap_8
X_1806_ net112 net147 VGND VGND VPWR VPWR _0330_ sky130_fd_sc_hd__nor2_1
X_2855_ clknet_leaf_3_clk _0110_ net241 VGND VGND VPWR VPWR regs.tx_data\[4\] sky130_fd_sc_hd__dfrtp_1
X_2786_ clknet_leaf_2_clk _0460_ net42 VGND VGND VPWR VPWR tx_fifo.fifo\[5\]\[7\]
+ sky130_fd_sc_hd__edfxtp_1
XFILLER_0_25_182 VGND VGND VPWR VPWR sky130_fd_sc_hd__fill_2
X_2924_ clknet_leaf_30_clk net291 net259 VGND VGND VPWR VPWR regs.rx_data\[4\] sky130_fd_sc_hd__dfrtp_1
XTAP_561 VGND VPWR sky130_fd_sc_hd__tapvpwrvgnd_1
XTAP_550 VGND VPWR sky130_fd_sc_hd__tapvpwrvgnd_1
X_1668_ net113 net159 VGND VGND VPWR VPWR _0199_ sky130_fd_sc_hd__nor2_1
XFILLER_0_40_141 VGND VGND VPWR VPWR sky130_fd_sc_hd__fill_2
X_1599_ rx_fifo.fifo\[15\]\[1\] net164 net162 rx_fifo.fifo\[8\]\[1\] rx_fifo.fifo\[10\]\[1\]
+ net167 VGND VGND VPWR VPWR _0803_ sky130_fd_sc_hd__a222oi_1
X_1737_ net113 _0863_ VGND VGND VPWR VPWR _0265_ sky130_fd_sc_hd__nor2_1
XFILLER_0_13_377 VGND VGND VPWR VPWR sky130_fd_sc_hd__fill_2
XTAP_594 VGND VPWR sky130_fd_sc_hd__tapvpwrvgnd_1
XTAP_583 VGND VPWR sky130_fd_sc_hd__tapvpwrvgnd_1
XTAP_572 VGND VPWR sky130_fd_sc_hd__tapvpwrvgnd_1
XFILLER_0_31_196 VGND VGND VPWR VPWR sky130_fd_sc_hd__fill_1
XFILLER_0_52_49 VGND VGND VPWR VPWR sky130_fd_sc_hd__fill_1
X_2640_ clknet_leaf_20_clk _0284_ net98 VGND VGND VPWR VPWR rx_fifo.fifo\[6\]\[3\]
+ sky130_fd_sc_hd__edfxtp_1
XFILLER_0_77_57 VPWR VGND VPWR VGND sky130_ef_sc_hd__decap_12
X_1453_ rx.baud_cnt\[8\] _0576_ _0673_ VGND VGND VPWR VPWR _0674_ sky130_fd_sc_hd__and3_1
X_2571_ clknet_leaf_23_clk _0324_ net84 VGND VGND VPWR VPWR rx_fifo.fifo\[2\]\[0\]
+ sky130_fd_sc_hd__edfxtp_1
X_1522_ net2 net3 VGND VGND VPWR VPWR _0731_ sky130_fd_sc_hd__lpflow_isobufsrc_1
X_1384_ tx.baud_cnt\[6\] _0598_ _0602_ _0609_ _0612_ VGND VGND VPWR VPWR _0623_ sky130_fd_sc_hd__o2111ai_1
XFILLER_0_26_50 VGND VGND VPWR VPWR sky130_fd_sc_hd__fill_2
X_2005_ tx_fifo.count\[2\] tx_fifo.count\[1\] tx_fifo.count\[0\] _0918_ tx_fifo.count\[3\]
+ VGND VGND VPWR VPWR _0927_ sky130_fd_sc_hd__o311ai_2
X_2907_ clknet_leaf_28_clk _0067_ net255 VGND VGND VPWR VPWR rx_fifo.tail\[2\] sky130_fd_sc_hd__dfrtp_4
XFILLER_0_60_269 VGND VGND VPWR VPWR sky130_fd_sc_hd__fill_1
X_2838_ clknet_leaf_15_clk _0124_ net247 VGND VGND VPWR VPWR regs.ier\[0\] sky130_fd_sc_hd__dfrtp_1
XFILLER_0_5_330 VGND VGND VPWR VPWR sky130_fd_sc_hd__decap_6
X_2769_ clknet_leaf_43_clk _0467_ net44 VGND VGND VPWR VPWR tx_fifo.fifo\[4\]\[6\]
+ sky130_fd_sc_hd__edfxtp_1
Xwire2 _0557_ VGND VGND VPWR VPWR net381 sky130_fd_sc_hd__buf_1
XTAP_391 VGND VPWR sky130_fd_sc_hd__tapvpwrvgnd_1
XTAP_380 VGND VPWR sky130_fd_sc_hd__tapvpwrvgnd_1
XPHY_64 VGND VGND VPWR VPWR sky130_fd_sc_hd__decap_3
XPHY_53 VGND VGND VPWR VPWR sky130_fd_sc_hd__decap_3
XPHY_20 VGND VGND VPWR VPWR sky130_fd_sc_hd__decap_3
XPHY_31 VGND VGND VPWR VPWR sky130_fd_sc_hd__decap_3
XPHY_42 VGND VGND VPWR VPWR sky130_fd_sc_hd__decap_3
XPHY_97 VGND VGND VPWR VPWR sky130_fd_sc_hd__decap_3
XPHY_86 VGND VGND VPWR VPWR sky130_fd_sc_hd__decap_3
XPHY_75 VGND VGND VPWR VPWR sky130_fd_sc_hd__decap_3
XFILLER_0_51_258 VPWR VGND VPWR VGND sky130_ef_sc_hd__decap_12
XFILLER_0_27_233 VGND VGND VPWR VPWR sky130_fd_sc_hd__fill_2
X_2623_ clknet_leaf_16_clk _0190_ net100 VGND VGND VPWR VPWR rx_fifo.fifo\[15\]\[8\]
+ sky130_fd_sc_hd__edfxtp_1
XFILLER_0_42_214 VGND VGND VPWR VPWR sky130_fd_sc_hd__fill_1
X_2554_ clknet_leaf_27_clk _0352_ net88 VGND VGND VPWR VPWR rx_fifo.fifo\[0\]\[5\]
+ sky130_fd_sc_hd__edfxtp_1
XFILLER_0_2_333 VPWR VGND VPWR VGND sky130_ef_sc_hd__decap_12
X_1367_ _0501_ tx.baud_cnt\[0\] _0605_ VGND VGND VPWR VPWR _0606_ sky130_fd_sc_hd__a21oi_1
X_1436_ rx.baud_cnt\[14\] _0659_ _0586_ VGND VGND VPWR VPWR _0660_ sky130_fd_sc_hd__o21ai_0
X_1505_ net2 net1 net3 VGND VGND VPWR VPWR _0714_ sky130_fd_sc_hd__or3_4
XFILLER_0_37_60 VPWR VGND VPWR VGND sky130_ef_sc_hd__decap_12
XFILLER_0_2_377 VPWR VGND VPWR VGND sky130_ef_sc_hd__decap_12
X_2485_ _1230_ _1231_ VGND VGND VPWR VPWR _1232_ sky130_fd_sc_hd__xnor2_1
XFILLER_0_77_133 VGND VGND VPWR VPWR sky130_fd_sc_hd__decap_6
XFILLER_0_77_111 VGND VGND VPWR VPWR sky130_fd_sc_hd__fill_1
XFILLER_0_53_81 VGND VGND VPWR VPWR sky130_fd_sc_hd__decap_3
X_1298_ rx_fifo.fifo\[7\]\[10\] net172 net164 rx_fifo.fifo\[15\]\[10\] VGND VGND VPWR
+ VPWR _0540_ sky130_fd_sc_hd__a22oi_2
XFILLER_0_77_177 VGND VGND VPWR VPWR sky130_fd_sc_hd__fill_1
XFILLER_0_18_266 VGND VGND VPWR VPWR sky130_fd_sc_hd__decap_8
XFILLER_0_14_461 VGND VGND VPWR VPWR sky130_fd_sc_hd__fill_2
XFILLER_0_68_188 VGND VGND VPWR VPWR sky130_fd_sc_hd__decap_8
XFILLER_0_64_394 VGND VGND VPWR VPWR sky130_fd_sc_hd__fill_2
XFILLER_0_24_214 VGND VGND VPWR VPWR sky130_fd_sc_hd__decap_3
XFILLER_0_24_203 VGND VGND VPWR VPWR sky130_fd_sc_hd__decap_4
XFILLER_0_58_59 VGND VGND VPWR VPWR sky130_fd_sc_hd__decap_4
XFILLER_0_58_26 VGND VGND VPWR VPWR sky130_fd_sc_hd__fill_2
XFILLER_0_58_15 VGND VGND VPWR VPWR sky130_fd_sc_hd__decap_6
X_2270_ net11 net331 _1132_ VGND VGND VPWR VPWR _0096_ sky130_fd_sc_hd__mux2_1
XFILLER_0_62_309 VGND VGND VPWR VPWR sky130_fd_sc_hd__fill_2
X_1985_ net223 net76 net218 VGND VGND VPWR VPWR _0911_ sky130_fd_sc_hd__a21oi_1
XFILLER_0_7_447 VGND VGND VPWR VPWR sky130_fd_sc_hd__fill_1
XFILLER_0_15_225 VPWR VGND VPWR VGND sky130_ef_sc_hd__decap_12
XFILLER_0_70_353 VGND VGND VPWR VPWR sky130_fd_sc_hd__decap_8
X_2606_ clknet_leaf_18_clk _0305_ net80 VGND VGND VPWR VPWR rx_fifo.fifo\[4\]\[2\]
+ sky130_fd_sc_hd__edfxtp_1
X_2537_ clknet_leaf_25_clk _0193_ net86 VGND VGND VPWR VPWR rx_fifo.fifo\[14\]\[10\]
+ sky130_fd_sc_hd__edfxtp_1
XFILLER_0_2_141 VGND VGND VPWR VPWR sky130_fd_sc_hd__decap_6
X_1419_ tx.baud_cnt\[3\] _0630_ net361 VGND VGND VPWR VPWR _0648_ sky130_fd_sc_hd__a21oi_1
XFILLER_0_54_3 VPWR VGND VPWR VGND sky130_ef_sc_hd__decap_12
XFILLER_0_48_70 VPWR VGND VPWR VGND sky130_ef_sc_hd__decap_12
X_2468_ net122 _1222_ _1223_ VGND VGND VPWR VPWR _0167_ sky130_fd_sc_hd__nor3_1
X_2399_ rx.shift_reg\[6\] rx.shift_reg\[7\] rx.shift_reg\[0\] rx.shift_reg\[1\] VGND
+ VGND VPWR VPWR _1193_ sky130_fd_sc_hd__nor4_1
XFILLER_0_46_361 VGND VGND VPWR VPWR sky130_fd_sc_hd__decap_3
Xfanout160 _0571_ VGND VGND VPWR VPWR net160 sky130_fd_sc_hd__buf_2
Xfanout182 _1126_ VGND VGND VPWR VPWR net182 sky130_fd_sc_hd__clkbuf_4
Xfanout171 _0527_ VGND VGND VPWR VPWR net171 sky130_fd_sc_hd__buf_4
X_1770_ net116 net150 VGND VGND VPWR VPWR _0299_ sky130_fd_sc_hd__nor2_1
XFILLER_0_60_49 VGND VGND VPWR VPWR sky130_fd_sc_hd__fill_1
XFILLER_0_44_309 VPWR VGND VPWR VGND sky130_ef_sc_hd__decap_12
XFILLER_0_29_317 VPWR VGND VPWR VGND sky130_ef_sc_hd__decap_12
X_2253_ net325 net182 VGND VGND VPWR VPWR _1129_ sky130_fd_sc_hd__nand2_1
X_2184_ tx_fifo.fifo\[5\]\[0\] net198 _1004_ tx_fifo.fifo\[14\]\[0\] net196 tx_fifo.fifo\[0\]\[0\]
+ VGND VGND VPWR VPWR _1077_ sky130_fd_sc_hd__a222oi_1
X_2322_ _0939_ _0948_ _0975_ VGND VGND VPWR VPWR _1153_ sky130_fd_sc_hd__nand3_1
XFILLER_0_75_401 VGND VGND VPWR VPWR sky130_fd_sc_hd__fill_1
XFILLER_0_34_83 VGND VGND VPWR VPWR sky130_fd_sc_hd__fill_1
XFILLER_0_62_139 VGND VGND VPWR VPWR sky130_fd_sc_hd__fill_1
X_1968_ net68 _0907_ VGND VGND VPWR VPWR _0489_ sky130_fd_sc_hd__nor2_1
X_1899_ net207 _0894_ VGND VGND VPWR VPWR _0897_ sky130_fd_sc_hd__nand2_4
XFILLER_0_7_222 VGND VGND VPWR VPWR sky130_fd_sc_hd__fill_2
XFILLER_0_3_461 VGND VGND VPWR VPWR sky130_fd_sc_hd__fill_2
XFILLER_0_11_261 VPWR VGND VPWR VGND sky130_ef_sc_hd__decap_12
XFILLER_0_53_117 VGND VGND VPWR VPWR sky130_fd_sc_hd__fill_1
XFILLER_0_26_309 VGND VGND VPWR VPWR sky130_fd_sc_hd__decap_8
XFILLER_0_61_161 VGND VGND VPWR VPWR sky130_fd_sc_hd__fill_1
Xhold5 regs.tx_data\[5\] VGND VGND VPWR VPWR net266 sky130_fd_sc_hd__dlygate4sd3_1
XTAP_209 VGND VPWR sky130_fd_sc_hd__tapvpwrvgnd_1
XFILLER_0_76_209 VGND VGND VPWR VPWR sky130_fd_sc_hd__fill_1
XFILLER_0_71_15 VPWR VGND VPWR VGND sky130_ef_sc_hd__decap_12
XFILLER_0_57_434 VGND VGND VPWR VPWR sky130_fd_sc_hd__decap_3
X_2940_ clknet_leaf_28_clk _0042_ net256 VGND VGND VPWR VPWR rx.bit_cnt\[1\] sky130_fd_sc_hd__dfrtp_2
X_1822_ net102 _0872_ VGND VGND VPWR VPWR _0335_ sky130_fd_sc_hd__nor2_1
X_1753_ net105 net152 VGND VGND VPWR VPWR _0272_ sky130_fd_sc_hd__nor2_1
X_2871_ clknet_leaf_6_clk _0097_ net241 VGND VGND VPWR VPWR regs.dlh\[3\] sky130_fd_sc_hd__dfrtp_1
XFILLER_0_40_301 VGND VGND VPWR VPWR sky130_fd_sc_hd__decap_6
XFILLER_0_29_169 VGND VGND VPWR VPWR sky130_fd_sc_hd__decap_6
XFILLER_0_4_258 VGND VGND VPWR VPWR sky130_fd_sc_hd__fill_2
XFILLER_0_4_247 VGND VGND VPWR VPWR sky130_fd_sc_hd__decap_4
XTAP_743 VGND VPWR sky130_fd_sc_hd__tapvpwrvgnd_1
XTAP_732 VGND VPWR sky130_fd_sc_hd__tapvpwrvgnd_1
XTAP_721 VGND VPWR sky130_fd_sc_hd__tapvpwrvgnd_1
XTAP_710 VGND VPWR sky130_fd_sc_hd__tapvpwrvgnd_1
XFILLER_0_52_194 VGND VGND VPWR VPWR sky130_fd_sc_hd__fill_2
X_1684_ net106 net158 VGND VGND VPWR VPWR _0206_ sky130_fd_sc_hd__nor2_1
XFILLER_0_40_389 VGND VGND VPWR VPWR sky130_fd_sc_hd__fill_1
Xmax_cap179 _0516_ VGND VGND VPWR VPWR net179 sky130_fd_sc_hd__clkbuf_2
XTAP_787 VGND VPWR sky130_fd_sc_hd__tapvpwrvgnd_1
XTAP_776 VGND VPWR sky130_fd_sc_hd__tapvpwrvgnd_1
XTAP_765 VGND VPWR sky130_fd_sc_hd__tapvpwrvgnd_1
XTAP_754 VGND VPWR sky130_fd_sc_hd__tapvpwrvgnd_1
X_2305_ net7 _1136_ VGND VGND VPWR VPWR _1139_ sky130_fd_sc_hd__nor2_1
X_2167_ tx_fifo.fifo\[7\]\[1\] _0996_ net191 tx_fifo.fifo\[8\]\[1\] net386 tx_fifo.fifo\[0\]\[1\]
+ VGND VGND VPWR VPWR _1061_ sky130_fd_sc_hd__a222oi_1
X_2236_ _0615_ _0913_ _1117_ VGND VGND VPWR VPWR _1118_ sky130_fd_sc_hd__a21oi_1
XFILLER_0_17_3 VPWR VGND VPWR VGND sky130_ef_sc_hd__decap_12
X_2098_ net228 net230 net224 net226 VGND VGND VPWR VPWR _0997_ sky130_fd_sc_hd__nor4_2
XFILLER_0_31_389 VGND VGND VPWR VPWR sky130_fd_sc_hd__decap_3
XFILLER_0_39_445 VGND VGND VPWR VPWR sky130_fd_sc_hd__decap_3
XFILLER_0_66_253 VGND VGND VPWR VPWR sky130_fd_sc_hd__decap_8
XFILLER_0_66_15 VGND VGND VPWR VPWR sky130_fd_sc_hd__fill_1
XFILLER_0_34_183 VPWR VGND VPWR VGND sky130_ef_sc_hd__decap_12
XFILLER_0_5_29 VPWR VGND VPWR VGND sky130_ef_sc_hd__decap_12
X_2021_ rx.state\[0\] _0937_ VGND VGND VPWR VPWR _0939_ sky130_fd_sc_hd__lpflow_inputiso1p_1
XFILLER_0_72_212 VGND VGND VPWR VPWR sky130_fd_sc_hd__fill_2
X_2923_ clknet_leaf_31_clk net298 net258 VGND VGND VPWR VPWR regs.rx_data\[3\] sky130_fd_sc_hd__dfrtp_1
X_1805_ net113 net147 VGND VGND VPWR VPWR _0331_ sky130_fd_sc_hd__nor2_1
X_2854_ clknet_leaf_7_clk _0111_ net241 VGND VGND VPWR VPWR regs.tx_data\[3\] sky130_fd_sc_hd__dfrtp_1
X_1736_ net115 net153 VGND VGND VPWR VPWR _0266_ sky130_fd_sc_hd__nor2_1
X_2785_ clknet_leaf_3_clk _0459_ _0006_ VGND VGND VPWR VPWR tx_fifo.fifo\[5\]\[6\]
+ sky130_fd_sc_hd__edfxtp_1
XTAP_584 VGND VPWR sky130_fd_sc_hd__tapvpwrvgnd_1
XTAP_573 VGND VPWR sky130_fd_sc_hd__tapvpwrvgnd_1
XTAP_562 VGND VPWR sky130_fd_sc_hd__tapvpwrvgnd_1
X_1598_ _0794_ _0802_ net4 VGND VGND VPWR VPWR net26 sky130_fd_sc_hd__o21a_1
XTAP_551 VGND VPWR sky130_fd_sc_hd__tapvpwrvgnd_1
XTAP_540 VGND VPWR sky130_fd_sc_hd__tapvpwrvgnd_1
X_1667_ net115 net159 VGND VGND VPWR VPWR _0200_ sky130_fd_sc_hd__nor2_1
XFILLER_0_40_197 VGND VGND VPWR VPWR sky130_fd_sc_hd__decap_8
XTAP_595 VGND VPWR sky130_fd_sc_hd__tapvpwrvgnd_1
X_2219_ _1100_ _1103_ net222 VGND VGND VPWR VPWR _0074_ sky130_fd_sc_hd__a21oi_1
XFILLER_0_63_245 VPWR VGND VPWR VGND sky130_ef_sc_hd__decap_12
XFILLER_0_63_223 VGND VGND VPWR VPWR sky130_fd_sc_hd__fill_1
XFILLER_0_48_242 VGND VGND VPWR VPWR sky130_fd_sc_hd__decap_6
XFILLER_0_31_175 VGND VGND VPWR VPWR sky130_fd_sc_hd__fill_1
XFILLER_0_31_153 VGND VGND VPWR VPWR sky130_fd_sc_hd__decap_8
XFILLER_0_6_3 VPWR VGND VPWR VGND sky130_ef_sc_hd__decap_12
XFILLER_0_54_234 VGND VGND VPWR VPWR sky130_fd_sc_hd__decap_8
XFILLER_0_50_462 VGND VGND VPWR VPWR sky130_fd_sc_hd__fill_1
X_2570_ clknet_leaf_25_clk _0336_ net85 VGND VGND VPWR VPWR rx_fifo.fifo\[1\]\[10\]
+ sky130_fd_sc_hd__edfxtp_1
XFILLER_0_6_309 VPWR VGND VPWR VGND sky130_ef_sc_hd__decap_12
XFILLER_0_77_69 VPWR VGND VPWR VGND sky130_ef_sc_hd__decap_12
X_1383_ tx.baud_cnt\[6\] _0598_ _0621_ _0585_ _0592_ VGND VGND VPWR VPWR _0622_ sky130_fd_sc_hd__a2111oi_1
X_1452_ divisor\[11\] net160 divisor\[12\] VGND VGND VPWR VPWR _0673_ sky130_fd_sc_hd__o21ai_1
X_1521_ net2 net1 net3 VGND VGND VPWR VPWR _0730_ sky130_fd_sc_hd__nor3b_2
XFILLER_0_22_197 VPWR VGND VPWR VGND sky130_ef_sc_hd__decap_12
XFILLER_0_10_348 VGND VGND VPWR VPWR sky130_fd_sc_hd__fill_2
XFILLER_0_77_337 VPWR VGND VPWR VGND sky130_ef_sc_hd__decap_12
X_2004_ _0512_ _0918_ VGND VGND VPWR VPWR _0926_ sky130_fd_sc_hd__nand2_1
XFILLER_0_45_278 VGND VGND VPWR VPWR sky130_fd_sc_hd__fill_2
X_2906_ clknet_leaf_28_clk _0068_ net260 VGND VGND VPWR VPWR rx_fifo.tail\[1\] sky130_fd_sc_hd__dfrtp_4
XFILLER_0_9_169 VGND VGND VPWR VPWR sky130_fd_sc_hd__decap_3
X_1719_ net106 net155 VGND VGND VPWR VPWR _0239_ sky130_fd_sc_hd__nor2_1
X_2699_ clknet_leaf_37_clk _0244_ net92 VGND VGND VPWR VPWR rx_fifo.fifo\[10\]\[7\]
+ sky130_fd_sc_hd__edfxtp_1
X_2837_ clknet_leaf_28_clk _0154_ net255 VGND VGND VPWR VPWR tx.bit_cnt\[2\] sky130_fd_sc_hd__dfrtp_1
X_2768_ clknet_leaf_0_clk _0466_ net44 VGND VGND VPWR VPWR tx_fifo.fifo\[4\]\[5\]
+ sky130_fd_sc_hd__edfxtp_1
XTAP_392 VGND VPWR sky130_fd_sc_hd__tapvpwrvgnd_1
XTAP_381 VGND VPWR sky130_fd_sc_hd__tapvpwrvgnd_1
XTAP_370 VGND VPWR sky130_fd_sc_hd__tapvpwrvgnd_1
XFILLER_0_6_83 VGND VGND VPWR VPWR sky130_fd_sc_hd__fill_1
Xwire3 _1010_ VGND VGND VPWR VPWR net382 sky130_fd_sc_hd__buf_1
XPHY_98 VGND VGND VPWR VPWR sky130_fd_sc_hd__decap_3
XPHY_87 VGND VGND VPWR VPWR sky130_fd_sc_hd__decap_3
XPHY_76 VGND VGND VPWR VPWR sky130_fd_sc_hd__decap_3
XPHY_65 VGND VGND VPWR VPWR sky130_fd_sc_hd__decap_3
XPHY_54 VGND VGND VPWR VPWR sky130_fd_sc_hd__decap_3
XPHY_43 VGND VGND VPWR VPWR sky130_fd_sc_hd__decap_3
XPHY_10 VGND VGND VPWR VPWR sky130_fd_sc_hd__decap_3
XPHY_21 VGND VGND VPWR VPWR sky130_fd_sc_hd__decap_3
XPHY_32 VGND VGND VPWR VPWR sky130_fd_sc_hd__decap_3
XFILLER_0_24_418 VGND VGND VPWR VPWR sky130_fd_sc_hd__fill_2
XFILLER_0_63_16 VGND VGND VPWR VPWR sky130_fd_sc_hd__fill_1
XFILLER_0_59_337 VGND VGND VPWR VPWR sky130_fd_sc_hd__fill_1
XFILLER_0_27_278 VGND VGND VPWR VPWR sky130_fd_sc_hd__fill_2
XFILLER_0_6_139 VGND VGND VPWR VPWR sky130_fd_sc_hd__fill_1
X_2553_ clknet_leaf_20_clk _0351_ net88 VGND VGND VPWR VPWR rx_fifo.fifo\[0\]\[4\]
+ sky130_fd_sc_hd__edfxtp_1
X_1504_ net2 net1 net3 VGND VGND VPWR VPWR _0713_ sky130_fd_sc_hd__nor3_1
X_2622_ clknet_leaf_28_clk _0189_ net100 VGND VGND VPWR VPWR rx_fifo.fifo\[15\]\[7\]
+ sky130_fd_sc_hd__edfxtp_1
XFILLER_0_2_389 VPWR VGND VPWR VGND sky130_ef_sc_hd__decap_12
XFILLER_0_2_345 VGND VGND VPWR VPWR sky130_fd_sc_hd__decap_8
X_1366_ divisor\[1\] tx.baud_cnt\[1\] VGND VGND VPWR VPWR _0605_ sky130_fd_sc_hd__xnor2_1
X_1435_ rx.baud_cnt\[12\] rx.baud_cnt\[13\] _0658_ VGND VGND VPWR VPWR _0659_ sky130_fd_sc_hd__and3_1
XFILLER_0_37_72 VGND VGND VPWR VPWR sky130_fd_sc_hd__fill_1
X_2484_ rx.shift_reg\[0\] rx.shift_reg\[1\] VGND VGND VPWR VPWR _1231_ sky130_fd_sc_hd__xor2_1
XFILLER_0_65_307 VGND VGND VPWR VPWR sky130_fd_sc_hd__decap_4
X_1297_ rx_fifo.fifo\[3\]\[10\] net176 net166 rx_fifo.fifo\[2\]\[10\] net162 rx_fifo.fifo\[8\]\[10\]
+ VGND VGND VPWR VPWR _0539_ sky130_fd_sc_hd__a222oi_1
XFILLER_0_20_421 VGND VGND VPWR VPWR sky130_fd_sc_hd__decap_6
XFILLER_0_74_115 VGND VGND VPWR VPWR sky130_fd_sc_hd__decap_4
XFILLER_0_47_307 VGND VGND VPWR VPWR sky130_fd_sc_hd__fill_1
XFILLER_0_70_321 VGND VGND VPWR VPWR sky130_fd_sc_hd__decap_3
XFILLER_0_55_384 VGND VGND VPWR VPWR sky130_fd_sc_hd__fill_2
X_1984_ net218 _0878_ _0910_ VGND VGND VPWR VPWR _0033_ sky130_fd_sc_hd__nor3_1
XFILLER_0_15_237 VGND VGND VPWR VPWR sky130_fd_sc_hd__decap_4
XFILLER_0_70_365 VPWR VGND VPWR VGND sky130_ef_sc_hd__decap_12
X_2536_ clknet_leaf_17_clk _0202_ net86 VGND VGND VPWR VPWR rx_fifo.fifo\[14\]\[9\]
+ sky130_fd_sc_hd__edfxtp_1
X_2605_ clknet_leaf_14_clk _0304_ _0024_ VGND VGND VPWR VPWR rx_fifo.fifo\[4\]\[1\]
+ sky130_fd_sc_hd__edfxtp_1
X_2467_ rx.baud_cnt\[14\] _0659_ net338 VGND VGND VPWR VPWR _1223_ sky130_fd_sc_hd__a21oi_1
XFILLER_0_23_281 VGND VGND VPWR VPWR sky130_fd_sc_hd__fill_1
XFILLER_0_23_270 VGND VGND VPWR VPWR sky130_fd_sc_hd__decap_3
XFILLER_0_2_197 VGND VGND VPWR VPWR sky130_fd_sc_hd__fill_2
X_1418_ net53 _0647_ VGND VGND VPWR VPWR _0368_ sky130_fd_sc_hd__nor2_1
X_1349_ divisor\[9\] _0573_ VGND VGND VPWR VPWR _0588_ sky130_fd_sc_hd__xnor2_1
XFILLER_0_48_82 VGND VGND VPWR VPWR sky130_fd_sc_hd__fill_2
X_2398_ net324 _0952_ VGND VGND VPWR VPWR _1192_ sky130_fd_sc_hd__nor2_1
XFILLER_0_46_373 VGND VGND VPWR VPWR sky130_fd_sc_hd__decap_3
Xfanout183 _1126_ VGND VGND VPWR VPWR net183 sky130_fd_sc_hd__buf_2
Xfanout172 _0525_ VGND VGND VPWR VPWR net172 sky130_fd_sc_hd__buf_4
Xfanout150 _0867_ VGND VGND VPWR VPWR net150 sky130_fd_sc_hd__buf_4
Xfanout161 _0538_ VGND VGND VPWR VPWR net161 sky130_fd_sc_hd__clkbuf_4
XFILLER_0_44_29 VPWR VGND VPWR VGND sky130_ef_sc_hd__decap_12
XFILLER_0_56_126 VPWR VGND VPWR VGND sky130_ef_sc_hd__decap_12
XFILLER_0_29_329 VGND VGND VPWR VPWR sky130_fd_sc_hd__fill_2
XFILLER_0_69_15 VPWR VGND VPWR VGND sky130_ef_sc_hd__decap_12
X_2321_ rx.sample_cnt\[1\] rx.sample_cnt\[0\] rx.sample_cnt\[2\] VGND VGND VPWR VPWR
+ _1152_ sky130_fd_sc_hd__a21oi_1
X_2252_ _0779_ _1125_ _1128_ VGND VGND VPWR VPWR _0082_ sky130_fd_sc_hd__o21ai_0
X_2183_ tx_fifo.fifo\[1\]\[0\] net190 _1009_ tx_fifo.fifo\[15\]\[0\] _1071_ VGND VGND
+ VPWR VPWR _1076_ sky130_fd_sc_hd__a221oi_1
XFILLER_0_75_446 VGND VGND VPWR VPWR sky130_fd_sc_hd__fill_2
XFILLER_0_47_159 VGND VGND VPWR VPWR sky130_fd_sc_hd__decap_3
XFILLER_0_47_137 VGND VGND VPWR VPWR sky130_fd_sc_hd__decap_3
X_1967_ net70 _0907_ VGND VGND VPWR VPWR _0490_ sky130_fd_sc_hd__nor2_1
XFILLER_0_7_245 VGND VGND VPWR VPWR sky130_fd_sc_hd__fill_2
X_1898_ net60 _0896_ VGND VGND VPWR VPWR _0413_ sky130_fd_sc_hd__nor2_1
XFILLER_0_11_273 VGND VGND VPWR VPWR sky130_fd_sc_hd__decap_6
X_2519_ _0628_ _0989_ _1140_ VGND VGND VPWR VPWR _1251_ sky130_fd_sc_hd__a21o_1
XFILLER_0_53_107 VGND VGND VPWR VPWR sky130_fd_sc_hd__decap_4
XFILLER_0_34_321 VGND VGND VPWR VPWR sky130_fd_sc_hd__fill_1
Xhold6 regs.tx_data\[4\] VGND VGND VPWR VPWR net267 sky130_fd_sc_hd__dlygate4sd3_1
XFILLER_0_71_27 VPWR VGND VPWR VGND sky130_ef_sc_hd__decap_12
XFILLER_0_69_273 VGND VGND VPWR VPWR sky130_fd_sc_hd__fill_2
X_2870_ clknet_leaf_15_clk _0098_ net249 VGND VGND VPWR VPWR regs.dlh\[2\] sky130_fd_sc_hd__dfrtp_1
XFILLER_0_57_457 VGND VGND VPWR VPWR sky130_fd_sc_hd__fill_2
XFILLER_0_29_104 VGND VGND VPWR VPWR sky130_fd_sc_hd__decap_8
X_1821_ net103 net146 VGND VGND VPWR VPWR _0337_ sky130_fd_sc_hd__nor2_1
X_1683_ net107 _0856_ VGND VGND VPWR VPWR _0207_ sky130_fd_sc_hd__nor2_1
Xclkbuf_leaf_10_clk clknet_2_2__leaf_clk VGND VGND VPWR VPWR clknet_leaf_10_clk sky130_fd_sc_hd__clkbuf_16
X_1752_ net107 net152 VGND VGND VPWR VPWR _0273_ sky130_fd_sc_hd__nor2_1
XFILLER_0_52_162 VPWR VGND VPWR VGND sky130_ef_sc_hd__decap_12
XFILLER_0_25_310 VPWR VGND VPWR VGND sky130_ef_sc_hd__decap_12
XFILLER_0_4_237 VGND VGND VPWR VPWR sky130_fd_sc_hd__decap_6
XTAP_777 VGND VPWR sky130_fd_sc_hd__tapvpwrvgnd_1
XTAP_766 VGND VPWR sky130_fd_sc_hd__tapvpwrvgnd_1
XTAP_755 VGND VPWR sky130_fd_sc_hd__tapvpwrvgnd_1
XTAP_744 VGND VPWR sky130_fd_sc_hd__tapvpwrvgnd_1
XTAP_733 VGND VPWR sky130_fd_sc_hd__tapvpwrvgnd_1
XTAP_722 VGND VPWR sky130_fd_sc_hd__tapvpwrvgnd_1
XTAP_711 VGND VPWR sky130_fd_sc_hd__tapvpwrvgnd_1
XTAP_700 VGND VPWR sky130_fd_sc_hd__tapvpwrvgnd_1
X_2304_ _0508_ _1136_ _1138_ VGND VGND VPWR VPWR _0123_ sky130_fd_sc_hd__a21oi_1
XFILLER_0_29_51 VGND VGND VPWR VPWR sky130_fd_sc_hd__fill_1
XFILLER_0_29_40 VGND VGND VPWR VPWR sky130_fd_sc_hd__decap_6
XFILLER_0_0_421 VGND VGND VPWR VPWR sky130_fd_sc_hd__decap_8
XTAP_788 VGND VPWR sky130_fd_sc_hd__tapvpwrvgnd_1
X_2097_ net225 net227 net228 net231 VGND VGND VPWR VPWR _0996_ sky130_fd_sc_hd__and4b_4
X_2166_ net275 _0991_ _0992_ tx.shift_reg\[2\] _1060_ VGND VGND VPWR VPWR _0064_ sky130_fd_sc_hd__a221o_1
X_2235_ _0990_ _1116_ VGND VGND VPWR VPWR _1117_ sky130_fd_sc_hd__nor2_1
XFILLER_0_63_449 VPWR VGND VPWR VGND sky130_ef_sc_hd__decap_12
XFILLER_0_16_321 VGND VGND VPWR VPWR sky130_fd_sc_hd__decap_6
XFILLER_0_16_365 VPWR VGND VPWR VGND sky130_ef_sc_hd__decap_12
XFILLER_0_34_195 VGND VGND VPWR VPWR sky130_fd_sc_hd__fill_1
XFILLER_0_19_181 VGND VGND VPWR VPWR sky130_fd_sc_hd__decap_8
XFILLER_0_66_27 VGND VGND VPWR VPWR sky130_fd_sc_hd__fill_1
XFILLER_0_22_368 VPWR VGND VPWR VGND sky130_ef_sc_hd__decap_12
X_2020_ rx.state\[0\] _0937_ VGND VGND VPWR VPWR _0938_ sky130_fd_sc_hd__nor2_1
X_2853_ clknet_leaf_5_clk _0112_ net240 VGND VGND VPWR VPWR regs.tx_data\[2\] sky130_fd_sc_hd__dfrtp_1
X_2922_ clknet_leaf_30_clk net289 net259 VGND VGND VPWR VPWR regs.rx_data\[2\] sky130_fd_sc_hd__dfrtp_1
X_1666_ net117 _0854_ VGND VGND VPWR VPWR _0201_ sky130_fd_sc_hd__nor2_1
X_1804_ net115 net147 VGND VGND VPWR VPWR _0332_ sky130_fd_sc_hd__nor2_1
X_1735_ net118 net153 VGND VGND VPWR VPWR _0267_ sky130_fd_sc_hd__nor2_1
X_2784_ clknet_leaf_2_clk _0458_ net42 VGND VGND VPWR VPWR tx_fifo.fifo\[5\]\[5\]
+ sky130_fd_sc_hd__edfxtp_1
XFILLER_0_56_93 VGND VGND VPWR VPWR sky130_fd_sc_hd__fill_1
XTAP_596 VGND VPWR sky130_fd_sc_hd__tapvpwrvgnd_1
XTAP_585 VGND VPWR sky130_fd_sc_hd__tapvpwrvgnd_1
XTAP_574 VGND VPWR sky130_fd_sc_hd__tapvpwrvgnd_1
XTAP_563 VGND VPWR sky130_fd_sc_hd__tapvpwrvgnd_1
X_1597_ _0564_ _0763_ _0798_ _0801_ VGND VGND VPWR VPWR _0802_ sky130_fd_sc_hd__o211ai_1
XTAP_552 VGND VPWR sky130_fd_sc_hd__tapvpwrvgnd_1
XTAP_541 VGND VPWR sky130_fd_sc_hd__tapvpwrvgnd_1
XTAP_530 VGND VPWR sky130_fd_sc_hd__tapvpwrvgnd_1
XFILLER_0_21_390 VGND VGND VPWR VPWR sky130_fd_sc_hd__fill_2
X_2149_ tx_fifo.fifo\[5\]\[3\] net198 net197 tx_fifo.fifo\[12\]\[3\] _1004_ tx_fifo.fifo\[14\]\[3\]
+ VGND VGND VPWR VPWR _1045_ sky130_fd_sc_hd__a222oi_1
X_2218_ _1090_ _1101_ _1102_ _1091_ VGND VGND VPWR VPWR _1103_ sky130_fd_sc_hd__a22oi_1
XFILLER_0_63_257 VPWR VGND VPWR VGND sky130_ef_sc_hd__decap_12
XFILLER_0_63_213 VGND VGND VPWR VPWR sky130_fd_sc_hd__decap_3
XFILLER_0_44_460 VGND VGND VPWR VPWR sky130_fd_sc_hd__decap_3
XFILLER_0_36_405 VPWR VGND VPWR VGND sky130_ef_sc_hd__decap_12
XFILLER_0_31_165 VGND VGND VPWR VPWR sky130_fd_sc_hd__decap_3
XFILLER_0_39_287 VGND VGND VPWR VPWR sky130_fd_sc_hd__fill_1
XFILLER_0_27_449 VPWR VGND VPWR VGND sky130_ef_sc_hd__decap_12
X_1520_ net235 net330 VGND VGND VPWR VPWR _0729_ sky130_fd_sc_hd__nand2_1
X_1382_ tx.baud_cnt\[11\] _0587_ VGND VGND VPWR VPWR _0621_ sky130_fd_sc_hd__xnor2_1
X_1451_ rx.baud_cnt\[10\] _0665_ VGND VGND VPWR VPWR _0672_ sky130_fd_sc_hd__nor2_1
XFILLER_0_77_349 VPWR VGND VPWR VGND sky130_ef_sc_hd__decap_12
XFILLER_0_77_305 VGND VGND VPWR VPWR sky130_fd_sc_hd__decap_3
X_2003_ _0919_ _0923_ _0924_ VGND VGND VPWR VPWR _0925_ sky130_fd_sc_hd__nand3_1
XFILLER_0_60_205 VGND VGND VPWR VPWR sky130_fd_sc_hd__decap_6
X_2905_ clknet_leaf_28_clk _0069_ net255 VGND VGND VPWR VPWR rx_fifo.tail\[0\] sky130_fd_sc_hd__dfrtp_1
X_2836_ clknet_leaf_37_clk _0125_ net255 VGND VGND VPWR VPWR tx.bit_cnt\[1\] sky130_fd_sc_hd__dfrtp_2
XFILLER_0_18_416 VGND VGND VPWR VPWR sky130_fd_sc_hd__decap_4
X_2698_ clknet_leaf_28_clk _0243_ _0016_ VGND VGND VPWR VPWR rx_fifo.fifo\[10\]\[6\]
+ sky130_fd_sc_hd__edfxtp_1
X_1718_ net108 net155 VGND VGND VPWR VPWR _0240_ sky130_fd_sc_hd__nor2_1
X_1649_ regs.rx_data\[6\] net125 VGND VGND VPWR VPWR _0846_ sky130_fd_sc_hd__nand2_1
XFILLER_0_13_143 VGND VGND VPWR VPWR sky130_fd_sc_hd__fill_1
X_2767_ clknet_leaf_0_clk _0465_ net44 VGND VGND VPWR VPWR tx_fifo.fifo\[4\]\[4\]
+ sky130_fd_sc_hd__edfxtp_1
XTAP_393 VGND VPWR sky130_fd_sc_hd__tapvpwrvgnd_1
XTAP_382 VGND VPWR sky130_fd_sc_hd__tapvpwrvgnd_1
XTAP_371 VGND VPWR sky130_fd_sc_hd__tapvpwrvgnd_1
XTAP_360 VGND VPWR sky130_fd_sc_hd__tapvpwrvgnd_1
XFILLER_0_76_360 VGND VGND VPWR VPWR sky130_fd_sc_hd__decap_4
XPHY_99 VGND VGND VPWR VPWR sky130_fd_sc_hd__decap_3
XPHY_88 VGND VGND VPWR VPWR sky130_fd_sc_hd__decap_3
XPHY_77 VGND VGND VPWR VPWR sky130_fd_sc_hd__decap_3
XPHY_66 VGND VGND VPWR VPWR sky130_fd_sc_hd__decap_3
XPHY_55 VGND VGND VPWR VPWR sky130_fd_sc_hd__decap_3
XPHY_44 VGND VGND VPWR VPWR sky130_fd_sc_hd__decap_3
XPHY_11 VGND VGND VPWR VPWR sky130_fd_sc_hd__decap_3
XPHY_22 VGND VGND VPWR VPWR sky130_fd_sc_hd__decap_3
XPHY_33 VGND VGND VPWR VPWR sky130_fd_sc_hd__decap_3
XFILLER_0_51_249 VGND VGND VPWR VPWR sky130_fd_sc_hd__fill_2
XFILLER_0_36_257 VGND VGND VPWR VPWR sky130_fd_sc_hd__fill_1
XFILLER_0_24_408 VGND VGND VPWR VPWR sky130_fd_sc_hd__fill_2
XFILLER_0_59_305 VPWR VGND VPWR VGND sky130_ef_sc_hd__decap_12
XFILLER_0_27_213 VGND VGND VPWR VPWR sky130_fd_sc_hd__decap_8
XFILLER_0_12_32 VGND VGND VPWR VPWR sky130_fd_sc_hd__decap_4
X_1503_ net283 _0701_ VGND VGND VPWR VPWR _0161_ sky130_fd_sc_hd__nor2_1
XFILLER_0_63_9 VGND VGND VPWR VPWR sky130_fd_sc_hd__decap_4
X_2552_ clknet_leaf_14_clk _0350_ net88 VGND VGND VPWR VPWR rx_fifo.fifo\[0\]\[3\]
+ sky130_fd_sc_hd__edfxtp_1
X_2621_ clknet_leaf_24_clk _0188_ net100 VGND VGND VPWR VPWR rx_fifo.fifo\[15\]\[6\]
+ sky130_fd_sc_hd__edfxtp_1
X_2483_ rx.shift_reg\[6\] rx.shift_reg\[7\] VGND VGND VPWR VPWR _1230_ sky130_fd_sc_hd__xor2_1
X_1365_ _0565_ _0603_ tx.baud_cnt\[2\] VGND VGND VPWR VPWR _0604_ sky130_fd_sc_hd__a21oi_1
X_1434_ rx.baud_cnt\[10\] rx.baud_cnt\[11\] _0656_ VGND VGND VPWR VPWR _0658_ sky130_fd_sc_hd__and3_1
X_1296_ _0520_ _0526_ VGND VGND VPWR VPWR _0538_ sky130_fd_sc_hd__nor2_1
XFILLER_0_77_113 VGND VGND VPWR VPWR sky130_fd_sc_hd__decap_3
XFILLER_0_53_50 VGND VGND VPWR VPWR sky130_fd_sc_hd__fill_2
X_2819_ clknet_leaf_42_clk _0421_ _0001_ VGND VGND VPWR VPWR tx_fifo.fifo\[9\]\[0\]
+ sky130_fd_sc_hd__edfxtp_1
XTAP_190 VGND VPWR sky130_fd_sc_hd__tapvpwrvgnd_1
XFILLER_0_74_27 VGND VGND VPWR VPWR sky130_fd_sc_hd__fill_1
XFILLER_0_59_146 VGND VGND VPWR VPWR sky130_fd_sc_hd__fill_1
XFILLER_0_7_405 VPWR VGND VPWR VGND sky130_ef_sc_hd__decap_12
X_2604_ clknet_leaf_13_clk _0302_ net80 VGND VGND VPWR VPWR rx_fifo.fifo\[4\]\[0\]
+ sky130_fd_sc_hd__edfxtp_1
XFILLER_0_70_377 VPWR VGND VPWR VGND sky130_ef_sc_hd__decap_12
XFILLER_0_70_300 VGND VGND VPWR VPWR sky130_fd_sc_hd__decap_8
X_1983_ net223 net76 tx_fifo.tail\[1\] VGND VGND VPWR VPWR _0910_ sky130_fd_sc_hd__a21oi_1
XFILLER_0_7_449 VPWR VGND VPWR VGND sky130_ef_sc_hd__decap_12
X_1417_ tx.baud_cnt\[5\] _0631_ VGND VGND VPWR VPWR _0647_ sky130_fd_sc_hd__xnor2_1
X_2535_ clknet_leaf_26_clk _0201_ net87 VGND VGND VPWR VPWR rx_fifo.fifo\[14\]\[8\]
+ sky130_fd_sc_hd__edfxtp_1
X_2466_ rx.baud_cnt\[14\] net338 _0659_ VGND VGND VPWR VPWR _1222_ sky130_fd_sc_hd__and3_1
X_1348_ divisor\[11\] _0574_ VGND VGND VPWR VPWR _0587_ sky130_fd_sc_hd__xnor2_1
X_2397_ net158 net91 VGND VGND VPWR VPWR _0204_ sky130_fd_sc_hd__nor2_1
X_1279_ _0519_ _0520_ VGND VGND VPWR VPWR _0521_ sky130_fd_sc_hd__nor2_1
XFILLER_0_65_127 VGND VGND VPWR VPWR sky130_fd_sc_hd__fill_2
XFILLER_0_21_219 VGND VGND VPWR VPWR sky130_fd_sc_hd__decap_4
Xfanout173 net174 VGND VGND VPWR VPWR net173 sky130_fd_sc_hd__buf_4
Xfanout151 _0866_ VGND VGND VPWR VPWR net151 sky130_fd_sc_hd__clkbuf_4
Xfanout162 _0537_ VGND VGND VPWR VPWR net162 sky130_fd_sc_hd__clkbuf_4
XFILLER_0_60_18 VGND VGND VPWR VPWR sky130_fd_sc_hd__fill_1
XFILLER_0_56_138 VGND VGND VPWR VPWR sky130_fd_sc_hd__fill_2
XFILLER_0_69_27 VPWR VGND VPWR VGND sky130_ef_sc_hd__decap_12
X_2251_ divisor\[11\] net183 VGND VGND VPWR VPWR _1128_ sky130_fd_sc_hd__nand2_1
X_2320_ net323 _1150_ VGND VGND VPWR VPWR _1151_ sky130_fd_sc_hd__nand2_1
X_2182_ tx_fifo.fifo\[3\]\[0\] net193 net186 tx_fifo.fifo\[6\]\[0\] net185 tx_fifo.fifo\[2\]\[0\]
+ VGND VGND VPWR VPWR _1075_ sky130_fd_sc_hd__a222oi_1
XFILLER_0_34_41 VGND VGND VPWR VPWR sky130_fd_sc_hd__decap_8
X_1966_ net72 _0907_ VGND VGND VPWR VPWR _0491_ sky130_fd_sc_hd__nor2_1
XFILLER_0_28_396 VPWR VGND VPWR VGND sky130_ef_sc_hd__decap_12
XFILLER_0_3_441 VGND VGND VPWR VPWR sky130_fd_sc_hd__decap_6
X_1897_ net62 _0896_ VGND VGND VPWR VPWR _0414_ sky130_fd_sc_hd__nor2_1
X_2449_ _1208_ _1209_ _1210_ VGND VGND VPWR VPWR _1211_ sky130_fd_sc_hd__nand3_1
X_2518_ net342 _1143_ _1144_ _1250_ VGND VGND VPWR VPWR _0154_ sky130_fd_sc_hd__o2bb2ai_1
XFILLER_0_38_149 VPWR VGND VPWR VGND sky130_ef_sc_hd__decap_12
Xhold7 regs.tx_data\[2\] VGND VGND VPWR VPWR net268 sky130_fd_sc_hd__dlygate4sd3_1
X_1820_ net105 net146 VGND VGND VPWR VPWR _0338_ sky130_fd_sc_hd__nor2_1
XFILLER_0_71_39 VPWR VGND VPWR VGND sky130_ef_sc_hd__decap_12
X_1682_ net109 _0856_ VGND VGND VPWR VPWR _0208_ sky130_fd_sc_hd__nor2_1
X_1751_ net109 net152 VGND VGND VPWR VPWR _0274_ sky130_fd_sc_hd__nor2_1
XFILLER_0_52_174 VPWR VGND VPWR VGND sky130_ef_sc_hd__decap_12
XFILLER_0_52_141 VGND VGND VPWR VPWR sky130_fd_sc_hd__decap_8
XFILLER_0_25_333 VGND VGND VPWR VPWR sky130_fd_sc_hd__decap_3
XFILLER_0_25_322 VGND VGND VPWR VPWR sky130_fd_sc_hd__decap_4
XFILLER_0_20_65 VGND VGND VPWR VPWR sky130_fd_sc_hd__fill_2
XTAP_789 VGND VPWR sky130_fd_sc_hd__tapvpwrvgnd_1
XTAP_778 VGND VPWR sky130_fd_sc_hd__tapvpwrvgnd_1
XTAP_767 VGND VPWR sky130_fd_sc_hd__tapvpwrvgnd_1
XTAP_756 VGND VPWR sky130_fd_sc_hd__tapvpwrvgnd_1
XTAP_745 VGND VPWR sky130_fd_sc_hd__tapvpwrvgnd_1
XTAP_734 VGND VPWR sky130_fd_sc_hd__tapvpwrvgnd_1
XTAP_723 VGND VPWR sky130_fd_sc_hd__tapvpwrvgnd_1
XTAP_712 VGND VPWR sky130_fd_sc_hd__tapvpwrvgnd_1
XTAP_701 VGND VPWR sky130_fd_sc_hd__tapvpwrvgnd_1
X_2303_ net8 _1136_ VGND VGND VPWR VPWR _1138_ sky130_fd_sc_hd__nor2_1
XFILLER_0_29_74 VPWR VGND VPWR VGND sky130_ef_sc_hd__decap_12
X_2234_ tx.bit_cnt\[2\] _1114_ _1115_ VGND VGND VPWR VPWR _1116_ sky130_fd_sc_hd__and3_2
XFILLER_0_45_51 VGND VGND VPWR VPWR sky130_fd_sc_hd__decap_4
X_2096_ tx_fifo.fifo\[5\]\[6\] net198 net197 tx_fifo.fifo\[12\]\[6\] VGND VGND VPWR
+ VPWR _0995_ sky130_fd_sc_hd__a22oi_1
XFILLER_0_0_42 VPWR VGND VPWR VGND sky130_ef_sc_hd__decap_12
X_2165_ net75 _1059_ VGND VGND VPWR VPWR _1060_ sky130_fd_sc_hd__nor2_1
XFILLER_0_71_461 VGND VGND VPWR VPWR sky130_fd_sc_hd__fill_2
XFILLER_0_28_171 VGND VGND VPWR VPWR sky130_fd_sc_hd__fill_1
X_1949_ tx_fifo.tail\[1\] net223 _0904_ VGND VGND VPWR VPWR _0905_ sky130_fd_sc_hd__nand3_4
XFILLER_0_31_369 VGND VGND VPWR VPWR sky130_fd_sc_hd__decap_8
XFILLER_0_16_377 VGND VGND VPWR VPWR sky130_fd_sc_hd__fill_1
XFILLER_0_66_233 VGND VGND VPWR VPWR sky130_fd_sc_hd__fill_2
XFILLER_0_66_299 VGND VGND VPWR VPWR sky130_fd_sc_hd__fill_1
XFILLER_0_34_141 VPWR VGND VPWR VGND sky130_ef_sc_hd__decap_12
XFILLER_0_66_39 VGND VGND VPWR VPWR sky130_fd_sc_hd__decap_3
XFILLER_0_57_211 VGND VGND VPWR VPWR sky130_fd_sc_hd__decap_4
XFILLER_0_57_200 VGND VGND VPWR VPWR sky130_fd_sc_hd__fill_1
XFILLER_0_57_266 VPWR VGND VPWR VGND sky130_ef_sc_hd__decap_12
XFILLER_0_57_233 VGND VGND VPWR VPWR sky130_fd_sc_hd__decap_3
XFILLER_0_53_461 VGND VGND VPWR VPWR sky130_fd_sc_hd__fill_2
X_1803_ net118 net147 VGND VGND VPWR VPWR _0333_ sky130_fd_sc_hd__nor2_1
X_2852_ clknet_leaf_38_clk _0113_ net240 VGND VGND VPWR VPWR regs.tx_data\[1\] sky130_fd_sc_hd__dfrtp_1
X_2783_ clknet_leaf_2_clk _0457_ net42 VGND VGND VPWR VPWR tx_fifo.fifo\[5\]\[4\]
+ sky130_fd_sc_hd__edfxtp_1
X_2921_ clknet_leaf_30_clk net285 net259 VGND VGND VPWR VPWR regs.rx_data\[1\] sky130_fd_sc_hd__dfrtp_1
X_1665_ net119 net159 VGND VGND VPWR VPWR _0202_ sky130_fd_sc_hd__nor2_1
X_1596_ net21 net238 _0800_ net239 _0734_ regs.lcr\[2\] VGND VGND VPWR VPWR _0801_
+ sky130_fd_sc_hd__a222oi_1
X_1734_ net120 net153 VGND VGND VPWR VPWR _0268_ sky130_fd_sc_hd__nor2_1
XFILLER_0_13_369 VGND VGND VPWR VPWR sky130_fd_sc_hd__decap_8
XFILLER_0_56_83 VGND VGND VPWR VPWR sky130_fd_sc_hd__fill_1
XTAP_597 VGND VPWR sky130_fd_sc_hd__tapvpwrvgnd_1
XTAP_586 VGND VPWR sky130_fd_sc_hd__tapvpwrvgnd_1
XTAP_575 VGND VPWR sky130_fd_sc_hd__tapvpwrvgnd_1
XTAP_564 VGND VPWR sky130_fd_sc_hd__tapvpwrvgnd_1
XTAP_553 VGND VPWR sky130_fd_sc_hd__tapvpwrvgnd_1
XTAP_542 VGND VPWR sky130_fd_sc_hd__tapvpwrvgnd_1
XTAP_531 VGND VPWR sky130_fd_sc_hd__tapvpwrvgnd_1
XTAP_520 VGND VPWR sky130_fd_sc_hd__tapvpwrvgnd_1
X_2217_ rx_fifo.count\[2\] _1096_ VGND VGND VPWR VPWR _1102_ sky130_fd_sc_hd__xnor2_1
XFILLER_0_22_3 VPWR VGND VPWR VGND sky130_ef_sc_hd__decap_12
XFILLER_0_36_417 VGND VGND VPWR VPWR sky130_fd_sc_hd__decap_3
X_2148_ tx_fifo.fifo\[4\]\[3\] net188 net184 tx_fifo.fifo\[2\]\[3\] _1043_ VGND VGND
+ VPWR VPWR _1044_ sky130_fd_sc_hd__a221oi_2
X_2079_ _0943_ _0947_ VGND VGND VPWR VPWR _0986_ sky130_fd_sc_hd__nand2_1
XFILLER_0_63_269 VGND VGND VPWR VPWR sky130_fd_sc_hd__decap_8
XFILLER_0_63_225 VGND VGND VPWR VPWR sky130_fd_sc_hd__decap_6
XFILLER_0_48_299 VGND VGND VPWR VPWR sky130_fd_sc_hd__decap_8
XFILLER_0_31_111 VGND VGND VPWR VPWR sky130_fd_sc_hd__fill_1
XFILLER_0_8_341 VGND VGND VPWR VPWR sky130_fd_sc_hd__fill_2
XFILLER_0_8_352 VGND VGND VPWR VPWR sky130_fd_sc_hd__decap_3
XFILLER_0_16_141 VGND VGND VPWR VPWR sky130_fd_sc_hd__fill_1
XFILLER_0_54_247 VGND VGND VPWR VPWR sky130_fd_sc_hd__decap_4
XFILLER_0_27_417 VGND VGND VPWR VPWR sky130_fd_sc_hd__decap_6
XFILLER_0_77_27 VGND VGND VPWR VPWR sky130_fd_sc_hd__fill_1
X_1450_ _0584_ _0669_ _0670_ VGND VGND VPWR VPWR _0671_ sky130_fd_sc_hd__or3_1
XFILLER_0_35_461 VGND VGND VPWR VPWR sky130_fd_sc_hd__fill_2
XFILLER_0_10_306 VGND VGND VPWR VPWR sky130_fd_sc_hd__fill_2
X_1381_ tx.baud_cnt\[9\] _0588_ VGND VGND VPWR VPWR _0620_ sky130_fd_sc_hd__xnor2_1
XFILLER_0_26_42 VGND VGND VPWR VPWR sky130_fd_sc_hd__decap_8
XFILLER_0_42_41 VGND VGND VPWR VPWR sky130_fd_sc_hd__decap_6
XFILLER_0_26_75 VGND VGND VPWR VPWR sky130_fd_sc_hd__fill_2
X_2002_ tx_fifo.count\[2\] tx_fifo.count\[1\] tx_fifo.count\[0\] tx_fifo.count\[3\]
+ VGND VGND VPWR VPWR _0924_ sky130_fd_sc_hd__a31o_1
XFILLER_0_45_236 VPWR VGND VPWR VGND sky130_ef_sc_hd__decap_12
XFILLER_0_45_225 VGND VGND VPWR VPWR sky130_fd_sc_hd__decap_8
X_2904_ clknet_leaf_24_clk _0136_ net261 VGND VGND VPWR VPWR rx_fifo.head\[3\] sky130_fd_sc_hd__dfrtp_4
XFILLER_0_42_96 VPWR VGND VPWR VGND sky130_ef_sc_hd__decap_12
X_2835_ clknet_leaf_37_clk _0126_ net255 VGND VGND VPWR VPWR tx.bit_cnt\[0\] sky130_fd_sc_hd__dfrtp_2
X_2766_ clknet_leaf_0_clk _0464_ net44 VGND VGND VPWR VPWR tx_fifo.fifo\[4\]\[3\]
+ sky130_fd_sc_hd__edfxtp_1
XFILLER_0_13_100 VPWR VGND VPWR VGND sky130_ef_sc_hd__decap_12
XFILLER_0_13_122 VPWR VGND VPWR VGND sky130_ef_sc_hd__decap_12
X_1579_ divisor\[2\] net237 VGND VGND VPWR VPWR _0784_ sky130_fd_sc_hd__nand2_1
X_1648_ net210 net115 VGND VGND VPWR VPWR _0189_ sky130_fd_sc_hd__nor2_1
X_1717_ net110 net155 VGND VGND VPWR VPWR _0241_ sky130_fd_sc_hd__nor2_1
X_2697_ clknet_leaf_30_clk _0242_ net92 VGND VGND VPWR VPWR rx_fifo.fifo\[10\]\[5\]
+ sky130_fd_sc_hd__edfxtp_1
XTAP_350 VGND VPWR sky130_fd_sc_hd__tapvpwrvgnd_1
XFILLER_0_6_41 VPWR VGND VPWR VGND sky130_ef_sc_hd__decap_12
XFILLER_0_13_177 VGND VGND VPWR VPWR sky130_fd_sc_hd__fill_1
XFILLER_0_68_306 VGND VGND VPWR VPWR sky130_fd_sc_hd__fill_2
XTAP_394 VGND VPWR sky130_fd_sc_hd__tapvpwrvgnd_1
XTAP_383 VGND VPWR sky130_fd_sc_hd__tapvpwrvgnd_1
XTAP_372 VGND VPWR sky130_fd_sc_hd__tapvpwrvgnd_1
XTAP_361 VGND VPWR sky130_fd_sc_hd__tapvpwrvgnd_1
XPHY_12 VGND VGND VPWR VPWR sky130_fd_sc_hd__decap_3
XPHY_89 VGND VGND VPWR VPWR sky130_fd_sc_hd__decap_3
XPHY_78 VGND VGND VPWR VPWR sky130_fd_sc_hd__decap_3
XPHY_67 VGND VGND VPWR VPWR sky130_fd_sc_hd__decap_3
XPHY_56 VGND VGND VPWR VPWR sky130_fd_sc_hd__decap_3
XPHY_45 VGND VGND VPWR VPWR sky130_fd_sc_hd__decap_3
XPHY_23 VGND VGND VPWR VPWR sky130_fd_sc_hd__decap_3
XPHY_34 VGND VGND VPWR VPWR sky130_fd_sc_hd__decap_3
XFILLER_0_51_206 VPWR VGND VPWR VGND sky130_ef_sc_hd__decap_12
XFILLER_0_59_317 VPWR VGND VPWR VGND sky130_ef_sc_hd__decap_12
X_2620_ clknet_leaf_21_clk _0187_ net100 VGND VGND VPWR VPWR rx_fifo.fifo\[15\]\[5\]
+ sky130_fd_sc_hd__edfxtp_1
XFILLER_0_42_239 VPWR VGND VPWR VGND sky130_ef_sc_hd__decap_12
XFILLER_0_27_225 VGND VGND VPWR VPWR sky130_fd_sc_hd__decap_8
X_1502_ _0701_ _0712_ VGND VGND VPWR VPWR _0168_ sky130_fd_sc_hd__nor2_1
X_2551_ clknet_leaf_17_clk _0349_ _0029_ VGND VGND VPWR VPWR rx_fifo.fifo\[0\]\[2\]
+ sky130_fd_sc_hd__edfxtp_1
X_1433_ rx.baud_cnt\[10\] _0656_ VGND VGND VPWR VPWR _0657_ sky130_fd_sc_hd__and2_0
XFILLER_0_50_283 VGND VGND VPWR VPWR sky130_fd_sc_hd__fill_1
XFILLER_0_10_147 VGND VGND VPWR VPWR sky130_fd_sc_hd__fill_1
X_2482_ _1227_ _1228_ VGND VGND VPWR VPWR _1229_ sky130_fd_sc_hd__xnor2_1
XFILLER_0_77_103 VGND VGND VPWR VPWR sky130_fd_sc_hd__decap_8
X_1364_ divisor\[0\] divisor\[1\] divisor\[2\] VGND VGND VPWR VPWR _0603_ sky130_fd_sc_hd__o21ai_1
X_1295_ rx_fifo.head\[0\] rx_fifo.head\[1\] _0526_ VGND VGND VPWR VPWR _0537_ sky130_fd_sc_hd__nor3_1
XFILLER_0_77_169 VGND VGND VPWR VPWR sky130_fd_sc_hd__decap_8
XFILLER_0_73_353 VGND VGND VPWR VPWR sky130_fd_sc_hd__decap_6
XFILLER_0_18_203 VGND VGND VPWR VPWR sky130_fd_sc_hd__fill_1
XFILLER_0_18_258 VGND VGND VPWR VPWR sky130_fd_sc_hd__decap_4
XFILLER_0_41_261 VPWR VGND VPWR VGND sky130_ef_sc_hd__decap_12
X_2818_ clknet_leaf_39_clk _0436_ net38 VGND VGND VPWR VPWR tx_fifo.fifo\[8\]\[7\]
+ sky130_fd_sc_hd__edfxtp_1
X_2749_ clknet_leaf_1_clk _0399_ _0010_ VGND VGND VPWR VPWR tx_fifo.fifo\[12\]\[2\]
+ sky130_fd_sc_hd__edfxtp_1
XTAP_191 VGND VPWR sky130_fd_sc_hd__tapvpwrvgnd_1
XTAP_180 VGND VPWR sky130_fd_sc_hd__tapvpwrvgnd_1
XFILLER_0_1_391 VGND VGND VPWR VPWR sky130_fd_sc_hd__fill_1
XFILLER_0_64_331 VGND VGND VPWR VPWR sky130_fd_sc_hd__decap_3
XFILLER_0_59_169 VGND VGND VPWR VPWR sky130_fd_sc_hd__fill_1
X_1982_ tx_fifo.tail\[2\] _0878_ _0909_ VGND VGND VPWR VPWR _0032_ sky130_fd_sc_hd__o21a_1
XFILLER_0_7_417 VPWR VGND VPWR VGND sky130_ef_sc_hd__decap_12
XFILLER_0_70_389 VPWR VGND VPWR VGND sky130_ef_sc_hd__decap_12
X_2603_ clknet_leaf_24_clk _0314_ net81 VGND VGND VPWR VPWR rx_fifo.fifo\[3\]\[10\]
+ sky130_fd_sc_hd__edfxtp_1
X_2534_ clknet_leaf_25_clk _0200_ net86 VGND VGND VPWR VPWR rx_fifo.fifo\[14\]\[7\]
+ sky130_fd_sc_hd__edfxtp_1
X_1416_ net52 _0632_ _0646_ VGND VGND VPWR VPWR _0369_ sky130_fd_sc_hd__nor3_1
X_1347_ _0566_ _0584_ VGND VGND VPWR VPWR _0586_ sky130_fd_sc_hd__nand2_1
X_2396_ net159 net91 VGND VGND VPWR VPWR _0193_ sky130_fd_sc_hd__nor2_1
X_2465_ _0900_ net55 VGND VGND VPWR VPWR _0444_ sky130_fd_sc_hd__nor2_1
XFILLER_0_11_434 VGND VGND VPWR VPWR sky130_fd_sc_hd__decap_3
X_1278_ rx_fifo.head\[1\] rx_fifo.head\[0\] VGND VGND VPWR VPWR _0520_ sky130_fd_sc_hd__nand2b_2
Xwire87 _0031_ VGND VGND VPWR VPWR net87 sky130_fd_sc_hd__buf_1
XFILLER_0_38_309 VPWR VGND VPWR VGND sky130_ef_sc_hd__decap_12
XFILLER_0_73_183 VGND VGND VPWR VPWR sky130_fd_sc_hd__fill_2
XFILLER_0_61_301 VGND VGND VPWR VPWR sky130_fd_sc_hd__fill_2
XFILLER_0_14_261 VPWR VGND VPWR VGND sky130_ef_sc_hd__decap_12
Xfanout152 _0865_ VGND VGND VPWR VPWR net152 sky130_fd_sc_hd__clkbuf_4
Xfanout163 _0536_ VGND VGND VPWR VPWR net163 sky130_fd_sc_hd__clkbuf_4
XFILLER_0_56_117 VGND VGND VPWR VPWR sky130_fd_sc_hd__decap_4
XFILLER_0_69_39 VPWR VGND VPWR VGND sky130_ef_sc_hd__decap_12
XFILLER_0_37_397 VPWR VGND VPWR VGND sky130_ef_sc_hd__decap_12
X_2250_ net331 net339 net182 VGND VGND VPWR VPWR _0081_ sky130_fd_sc_hd__mux2_1
X_2181_ _1072_ _1073_ VGND VGND VPWR VPWR _1074_ sky130_fd_sc_hd__nand2_1
XFILLER_0_19_9 VGND VGND VPWR VPWR sky130_fd_sc_hd__fill_1
XFILLER_0_75_426 VPWR VGND VPWR VGND sky130_ef_sc_hd__decap_12
XFILLER_0_50_85 VGND VGND VPWR VPWR sky130_fd_sc_hd__decap_4
XFILLER_0_47_106 VGND VGND VPWR VPWR sky130_fd_sc_hd__decap_6
XFILLER_0_28_353 VGND VGND VPWR VPWR sky130_fd_sc_hd__decap_8
X_1965_ net207 _0904_ VGND VGND VPWR VPWR _0907_ sky130_fd_sc_hd__nand2_4
XFILLER_0_7_225 VPWR VGND VPWR VGND sky130_ef_sc_hd__decap_12
XFILLER_0_59_83 VGND VGND VPWR VPWR sky130_fd_sc_hd__fill_2
XFILLER_0_43_389 VGND VGND VPWR VPWR sky130_fd_sc_hd__decap_3
XFILLER_0_43_356 VGND VGND VPWR VPWR sky130_fd_sc_hd__fill_1
X_2517_ tx.bit_cnt\[2\] _1145_ VGND VGND VPWR VPWR _1250_ sky130_fd_sc_hd__xor2_1
X_1896_ net64 _0896_ VGND VGND VPWR VPWR _0415_ sky130_fd_sc_hd__nor2_1
X_2448_ rx_fifo.fifo\[4\]\[7\] net174 net169 rx_fifo.fifo\[6\]\[7\] VGND VGND VPWR
+ VPWR _1210_ sky130_fd_sc_hd__a22oi_1
X_2379_ tx_fifo.fifo\[13\]\[7\] _0999_ _1005_ tx_fifo.fifo\[11\]\[7\] net188 tx_fifo.fifo\[4\]\[7\]
+ VGND VGND VPWR VPWR _1177_ sky130_fd_sc_hd__a222oi_1
XFILLER_0_66_404 VPWR VGND VPWR VGND sky130_ef_sc_hd__decap_12
XFILLER_0_38_139 VGND VGND VPWR VPWR sky130_fd_sc_hd__fill_1
Xhold8 regs.tx_data\[1\] VGND VGND VPWR VPWR net269 sky130_fd_sc_hd__dlygate4sd3_1
XFILLER_0_72_418 VGND VGND VPWR VPWR sky130_fd_sc_hd__fill_2
X_1750_ net111 net152 VGND VGND VPWR VPWR _0275_ sky130_fd_sc_hd__nor2_1
XFILLER_0_4_206 VGND VGND VPWR VPWR sky130_fd_sc_hd__fill_1
X_1681_ net111 net158 VGND VGND VPWR VPWR _0209_ sky130_fd_sc_hd__nor2_1
XFILLER_0_52_186 VGND VGND VPWR VPWR sky130_fd_sc_hd__decap_8
XFILLER_0_40_326 VGND VGND VPWR VPWR sky130_fd_sc_hd__fill_1
XFILLER_0_25_378 VPWR VGND VPWR VGND sky130_ef_sc_hd__decap_12
XTAP_779 VGND VPWR sky130_fd_sc_hd__tapvpwrvgnd_1
XTAP_768 VGND VPWR sky130_fd_sc_hd__tapvpwrvgnd_1
XTAP_757 VGND VPWR sky130_fd_sc_hd__tapvpwrvgnd_1
XTAP_746 VGND VPWR sky130_fd_sc_hd__tapvpwrvgnd_1
XTAP_735 VGND VPWR sky130_fd_sc_hd__tapvpwrvgnd_1
XTAP_724 VGND VPWR sky130_fd_sc_hd__tapvpwrvgnd_1
XTAP_713 VGND VPWR sky130_fd_sc_hd__tapvpwrvgnd_1
XTAP_702 VGND VPWR sky130_fd_sc_hd__tapvpwrvgnd_1
X_2302_ _0507_ _1136_ _1137_ VGND VGND VPWR VPWR _0122_ sky130_fd_sc_hd__a21oi_1
XFILLER_0_29_86 VGND VGND VPWR VPWR sky130_fd_sc_hd__decap_3
X_2233_ data_bits\[1\] tx.bit_cnt\[1\] VGND VGND VPWR VPWR _1115_ sky130_fd_sc_hd__xnor2_1
X_2164_ _1054_ _1058_ VGND VGND VPWR VPWR _1059_ sky130_fd_sc_hd__nor2_1
X_2095_ net228 net230 net224 net226 VGND VGND VPWR VPWR _0994_ sky130_fd_sc_hd__nor4bb_1
XFILLER_0_0_54 VGND VGND VPWR VPWR sky130_fd_sc_hd__fill_2
XFILLER_0_75_289 VGND VGND VPWR VPWR sky130_fd_sc_hd__fill_1
XFILLER_0_71_440 VGND VGND VPWR VPWR sky130_fd_sc_hd__decap_8
XFILLER_0_63_418 VGND VGND VPWR VPWR sky130_fd_sc_hd__decap_4
XFILLER_0_43_164 VGND VGND VPWR VPWR sky130_fd_sc_hd__decap_4
XFILLER_0_43_142 VGND VGND VPWR VPWR sky130_fd_sc_hd__decap_4
X_1948_ tx_fifo.tail\[2\] tx_fifo.tail\[3\] VGND VGND VPWR VPWR _0904_ sky130_fd_sc_hd__nor2_4
XFILLER_0_9_63 VGND VGND VPWR VPWR sky130_fd_sc_hd__fill_1
X_1879_ net64 _0893_ VGND VGND VPWR VPWR _0399_ sky130_fd_sc_hd__nor2_1
XFILLER_0_54_429 VGND VGND VPWR VPWR sky130_fd_sc_hd__decap_3
XFILLER_0_39_437 VGND VGND VPWR VPWR sky130_fd_sc_hd__decap_8
XFILLER_0_62_462 VGND VGND VPWR VPWR sky130_fd_sc_hd__fill_1
XFILLER_0_34_197 VPWR VGND VPWR VGND sky130_ef_sc_hd__decap_12
XFILLER_0_34_153 VGND VGND VPWR VPWR sky130_fd_sc_hd__fill_2
XFILLER_0_34_120 VPWR VGND VPWR VGND sky130_ef_sc_hd__decap_12
XFILLER_0_30_370 VGND VGND VPWR VPWR sky130_fd_sc_hd__fill_2
XFILLER_0_57_223 VGND VGND VPWR VPWR sky130_fd_sc_hd__fill_1
Xclkbuf_2_3__f_clk clknet_0_clk VGND VGND VPWR VPWR clknet_2_3__leaf_clk sky130_fd_sc_hd__clkbuf_16
X_2920_ clknet_leaf_31_clk net311 net257 VGND VGND VPWR VPWR regs.rx_data\[0\] sky130_fd_sc_hd__dfrtp_1
XFILLER_0_72_204 VGND VGND VPWR VPWR sky130_fd_sc_hd__decap_8
XFILLER_0_57_278 VGND VGND VPWR VPWR sky130_fd_sc_hd__fill_2
X_1802_ net120 _0871_ VGND VGND VPWR VPWR _0334_ sky130_fd_sc_hd__nor2_1
X_1733_ _0857_ _0859_ VGND VGND VPWR VPWR _0863_ sky130_fd_sc_hd__nand2_1
X_2851_ clknet_leaf_5_clk _0114_ net240 VGND VGND VPWR VPWR regs.tx_data\[0\] sky130_fd_sc_hd__dfrtp_1
X_2782_ clknet_leaf_2_clk _0456_ net42 VGND VGND VPWR VPWR tx_fifo.fifo\[5\]\[3\]
+ sky130_fd_sc_hd__edfxtp_1
XFILLER_0_31_54 VGND VGND VPWR VPWR sky130_fd_sc_hd__fill_2
X_1595_ net236 _0507_ _0799_ VGND VGND VPWR VPWR _0800_ sky130_fd_sc_hd__o21ai_0
XTAP_543 VGND VPWR sky130_fd_sc_hd__tapvpwrvgnd_1
XTAP_532 VGND VPWR sky130_fd_sc_hd__tapvpwrvgnd_1
XTAP_521 VGND VPWR sky130_fd_sc_hd__tapvpwrvgnd_1
XTAP_510 VGND VPWR sky130_fd_sc_hd__tapvpwrvgnd_1
X_1664_ rx_fifo.tail\[2\] rx_fifo.tail\[3\] _0853_ VGND VGND VPWR VPWR _0854_ sky130_fd_sc_hd__nand3_2
XFILLER_0_40_189 VGND VGND VPWR VPWR sky130_fd_sc_hd__decap_6
XFILLER_0_0_253 VPWR VGND VPWR VGND sky130_ef_sc_hd__decap_12
XFILLER_0_13_337 VPWR VGND VPWR VGND sky130_ef_sc_hd__decap_12
XFILLER_0_56_40 VGND VGND VPWR VPWR sky130_fd_sc_hd__decap_4
XTAP_598 VGND VPWR sky130_fd_sc_hd__tapvpwrvgnd_1
XTAP_587 VGND VPWR sky130_fd_sc_hd__tapvpwrvgnd_1
XTAP_576 VGND VPWR sky130_fd_sc_hd__tapvpwrvgnd_1
XTAP_565 VGND VPWR sky130_fd_sc_hd__tapvpwrvgnd_1
XTAP_554 VGND VPWR sky130_fd_sc_hd__tapvpwrvgnd_1
X_2216_ rx_fifo.count\[2\] _0514_ VGND VGND VPWR VPWR _1101_ sky130_fd_sc_hd__xor2_1
X_2147_ tx_fifo.fifo\[13\]\[3\] _0999_ net189 tx_fifo.fifo\[1\]\[3\] VGND VGND VPWR
+ VPWR _1043_ sky130_fd_sc_hd__a22o_1
XFILLER_0_15_3 VGND VGND VPWR VPWR sky130_fd_sc_hd__decap_6
XFILLER_0_48_289 VGND VGND VPWR VPWR sky130_fd_sc_hd__decap_6
X_2078_ parity_en _0985_ _0984_ _0981_ VGND VGND VPWR VPWR _0052_ sky130_fd_sc_hd__o211ai_1
XFILLER_0_71_281 VPWR VGND VPWR VGND sky130_ef_sc_hd__decap_12
XFILLER_0_12_392 VGND VGND VPWR VPWR sky130_fd_sc_hd__decap_4
XFILLER_0_39_223 VGND VGND VPWR VPWR sky130_fd_sc_hd__fill_1
XFILLER_0_39_267 VGND VGND VPWR VPWR sky130_fd_sc_hd__fill_2
X_1380_ tx.baud_cnt\[8\] _0613_ VGND VGND VPWR VPWR _0619_ sky130_fd_sc_hd__xnor2_1
X_2001_ tx_fifo.count\[3\] tx_fifo.count\[2\] tx_fifo.count\[1\] tx_fifo.count\[0\]
+ VGND VGND VPWR VPWR _0923_ sky130_fd_sc_hd__nand4_2
X_2903_ clknet_leaf_24_clk _0070_ net261 VGND VGND VPWR VPWR rx_fifo.head\[2\] sky130_fd_sc_hd__dfrtp_1
XFILLER_0_9_117 VGND VGND VPWR VPWR sky130_fd_sc_hd__decap_3
XFILLER_0_60_218 VGND VGND VPWR VPWR sky130_fd_sc_hd__decap_4
XFILLER_0_45_248 VPWR VGND VPWR VGND sky130_ef_sc_hd__decap_12
X_2696_ clknet_leaf_28_clk _0241_ net92 VGND VGND VPWR VPWR rx_fifo.fifo\[10\]\[4\]
+ sky130_fd_sc_hd__edfxtp_1
X_1716_ net112 net155 VGND VGND VPWR VPWR _0242_ sky130_fd_sc_hd__nor2_1
X_2834_ clknet_leaf_39_clk _0420_ net57 VGND VGND VPWR VPWR tx_fifo.fifo\[10\]\[7\]
+ sky130_fd_sc_hd__edfxtp_1
XFILLER_0_13_134 VGND VGND VPWR VPWR sky130_fd_sc_hd__decap_3
X_2765_ clknet_leaf_1_clk _0463_ _0008_ VGND VGND VPWR VPWR tx_fifo.fifo\[4\]\[2\]
+ sky130_fd_sc_hd__edfxtp_1
X_1578_ _0778_ _0783_ net4 VGND VGND VPWR VPWR net27 sky130_fd_sc_hd__o21a_1
XTAP_384 VGND VPWR sky130_fd_sc_hd__tapvpwrvgnd_1
XTAP_373 VGND VPWR sky130_fd_sc_hd__tapvpwrvgnd_1
X_1647_ regs.rx_data\[7\] net126 VGND VGND VPWR VPWR _0845_ sky130_fd_sc_hd__nand2_2
XTAP_362 VGND VPWR sky130_fd_sc_hd__tapvpwrvgnd_1
XTAP_351 VGND VPWR sky130_fd_sc_hd__tapvpwrvgnd_1
XTAP_340 VGND VPWR sky130_fd_sc_hd__tapvpwrvgnd_1
XFILLER_0_6_53 VPWR VGND VPWR VGND sky130_ef_sc_hd__decap_12
XTAP_395 VGND VPWR sky130_fd_sc_hd__tapvpwrvgnd_1
XPHY_46 VGND VGND VPWR VPWR sky130_fd_sc_hd__decap_3
XPHY_13 VGND VGND VPWR VPWR sky130_fd_sc_hd__decap_3
XPHY_24 VGND VGND VPWR VPWR sky130_fd_sc_hd__decap_3
XPHY_35 VGND VGND VPWR VPWR sky130_fd_sc_hd__decap_3
XFILLER_0_51_218 VGND VGND VPWR VPWR sky130_fd_sc_hd__decap_3
XPHY_79 VGND VGND VPWR VPWR sky130_fd_sc_hd__decap_3
XPHY_68 VGND VGND VPWR VPWR sky130_fd_sc_hd__decap_3
XPHY_57 VGND VGND VPWR VPWR sky130_fd_sc_hd__decap_3
XFILLER_0_8_183 VPWR VGND VPWR VGND sky130_ef_sc_hd__decap_12
XFILLER_0_17_462 VGND VGND VPWR VPWR sky130_fd_sc_hd__fill_1
XFILLER_0_32_421 VPWR VGND VPWR VGND sky130_ef_sc_hd__decap_12
XFILLER_0_67_384 VGND VGND VPWR VPWR sky130_fd_sc_hd__decap_8
XFILLER_0_59_329 VGND VGND VPWR VPWR sky130_fd_sc_hd__decap_6
X_2550_ clknet_leaf_17_clk _0348_ net88 VGND VGND VPWR VPWR rx_fifo.fifo\[0\]\[1\]
+ sky130_fd_sc_hd__edfxtp_1
XFILLER_0_50_251 VGND VGND VPWR VPWR sky130_fd_sc_hd__fill_1
X_1363_ tx.baud_cnt\[4\] _0601_ VGND VGND VPWR VPWR _0602_ sky130_fd_sc_hd__xnor2_1
X_1501_ net283 net375 VGND VGND VPWR VPWR _0712_ sky130_fd_sc_hd__xnor2_1
X_1432_ rx.baud_cnt\[9\] rx.baud_cnt\[8\] _0655_ VGND VGND VPWR VPWR _0656_ sky130_fd_sc_hd__and3_1
XFILLER_0_37_20 VGND VGND VPWR VPWR sky130_fd_sc_hd__decap_3
X_2481_ rx.shift_reg\[2\] rx.shift_reg\[3\] VGND VGND VPWR VPWR _1228_ sky130_fd_sc_hd__xor2_1
X_1294_ _0520_ _0523_ VGND VGND VPWR VPWR _0536_ sky130_fd_sc_hd__nor2_1
XFILLER_0_73_332 VGND VGND VPWR VPWR sky130_fd_sc_hd__fill_1
XFILLER_0_41_273 VGND VGND VPWR VPWR sky130_fd_sc_hd__decap_4
X_2748_ clknet_leaf_7_clk _0398_ net46 VGND VGND VPWR VPWR tx_fifo.fifo\[12\]\[1\]
+ sky130_fd_sc_hd__edfxtp_1
X_2679_ clknet_leaf_16_clk _0268_ net95 VGND VGND VPWR VPWR rx_fifo.fifo\[8\]\[9\]
+ sky130_fd_sc_hd__edfxtp_1
X_2817_ clknet_leaf_4_clk _0435_ net38 VGND VGND VPWR VPWR tx_fifo.fifo\[8\]\[6\]
+ sky130_fd_sc_hd__edfxtp_1
XTAP_192 VGND VPWR sky130_fd_sc_hd__tapvpwrvgnd_1
XTAP_181 VGND VPWR sky130_fd_sc_hd__tapvpwrvgnd_1
XTAP_170 VGND VPWR sky130_fd_sc_hd__tapvpwrvgnd_1
XFILLER_0_49_351 VGND VGND VPWR VPWR sky130_fd_sc_hd__fill_1
XFILLER_0_24_207 VGND VGND VPWR VPWR sky130_fd_sc_hd__fill_1
XFILLER_0_74_29 VPWR VGND VPWR VGND sky130_ef_sc_hd__decap_12
XFILLER_0_67_192 VGND VGND VPWR VPWR sky130_fd_sc_hd__fill_1
X_1981_ tx_fifo.tail\[2\] _0878_ net218 VGND VGND VPWR VPWR _0909_ sky130_fd_sc_hd__a21oi_1
XFILLER_0_7_429 VPWR VGND VPWR VGND sky130_ef_sc_hd__decap_12
Xclkbuf_leaf_40_clk clknet_2_0__leaf_clk VGND VGND VPWR VPWR clknet_leaf_40_clk sky130_fd_sc_hd__clkbuf_16
X_2602_ clknet_leaf_23_clk _0323_ net81 VGND VGND VPWR VPWR rx_fifo.fifo\[3\]\[9\]
+ sky130_fd_sc_hd__edfxtp_1
X_2533_ clknet_leaf_29_clk _0199_ net86 VGND VGND VPWR VPWR rx_fifo.fifo\[14\]\[6\]
+ sky130_fd_sc_hd__edfxtp_1
XFILLER_0_23_262 VGND VGND VPWR VPWR sky130_fd_sc_hd__decap_8
XFILLER_0_11_446 VGND VGND VPWR VPWR sky130_fd_sc_hd__fill_2
XFILLER_0_11_457 VGND VGND VPWR VPWR sky130_fd_sc_hd__decap_6
X_1415_ tx.baud_cnt\[5\] _0631_ net370 VGND VGND VPWR VPWR _0646_ sky130_fd_sc_hd__a21oi_1
X_1346_ divisor\[15\] divisor\[14\] net214 _0578_ VGND VGND VPWR VPWR _0585_ sky130_fd_sc_hd__nor4_2
X_2395_ net210 net90 VGND VGND VPWR VPWR _0182_ sky130_fd_sc_hd__nor2_1
X_2464_ net120 net117 net90 _1221_ VGND VGND VPWR VPWR _0140_ sky130_fd_sc_hd__nand4_1
XFILLER_0_65_107 VGND VGND VPWR VPWR sky130_fd_sc_hd__decap_4
X_1277_ rx_fifo.head\[3\] net234 VGND VGND VPWR VPWR _0519_ sky130_fd_sc_hd__nand2_2
XFILLER_0_3_87 VGND VGND VPWR VPWR sky130_fd_sc_hd__fill_2
Xclkbuf_leaf_31_clk clknet_2_1__leaf_clk VGND VGND VPWR VPWR clknet_leaf_31_clk sky130_fd_sc_hd__clkbuf_16
Xfanout120 _0843_ VGND VGND VPWR VPWR net120 sky130_fd_sc_hd__clkbuf_4
XFILLER_0_14_273 VGND VGND VPWR VPWR sky130_fd_sc_hd__decap_4
Xfanout175 _0521_ VGND VGND VPWR VPWR net175 sky130_fd_sc_hd__clkbuf_4
Xfanout164 _0535_ VGND VGND VPWR VPWR net164 sky130_fd_sc_hd__buf_4
Xfanout153 _0863_ VGND VGND VPWR VPWR net153 sky130_fd_sc_hd__clkbuf_4
Xclkbuf_leaf_22_clk clknet_2_3__leaf_clk VGND VGND VPWR VPWR clknet_leaf_22_clk sky130_fd_sc_hd__clkbuf_16
XFILLER_0_37_365 VPWR VGND VPWR VGND sky130_ef_sc_hd__decap_12
XFILLER_0_64_195 VGND VGND VPWR VPWR sky130_fd_sc_hd__fill_1
XFILLER_0_64_173 VPWR VGND VPWR VGND sky130_ef_sc_hd__decap_12
X_2180_ tx_fifo.fifo\[12\]\[0\] _0994_ net385 tx_fifo.fifo\[10\]\[0\] tx_fifo.fifo\[8\]\[0\]
+ _1002_ VGND VGND VPWR VPWR _1073_ sky130_fd_sc_hd__a222oi_1
XFILLER_0_20_298 VGND VGND VPWR VPWR sky130_fd_sc_hd__decap_4
XFILLER_0_75_438 VGND VGND VPWR VPWR sky130_fd_sc_hd__decap_8
XFILLER_0_47_129 VGND VGND VPWR VPWR sky130_fd_sc_hd__decap_8
XFILLER_0_75_449 VGND VGND VPWR VPWR sky130_fd_sc_hd__decap_8
Xclkbuf_leaf_13_clk clknet_2_2__leaf_clk VGND VGND VPWR VPWR clknet_leaf_13_clk sky130_fd_sc_hd__clkbuf_16
XFILLER_0_50_42 VPWR VGND VPWR VGND sky130_ef_sc_hd__decap_12
X_1895_ net66 _0896_ VGND VGND VPWR VPWR _0416_ sky130_fd_sc_hd__nor2_1
XFILLER_0_7_237 VGND VGND VPWR VPWR sky130_fd_sc_hd__decap_3
X_1964_ net60 _0906_ VGND VGND VPWR VPWR _0477_ sky130_fd_sc_hd__nor2_1
X_2447_ rx_fifo.fifo\[3\]\[7\] net177 net163 rx_fifo.fifo\[5\]\[7\] VGND VGND VPWR
+ VPWR _1209_ sky130_fd_sc_hd__a22oi_1
X_2516_ net320 net14 net123 VGND VGND VPWR VPWR _0153_ sky130_fd_sc_hd__mux2_1
XFILLER_0_11_210 VGND VGND VPWR VPWR sky130_fd_sc_hd__decap_3
X_1329_ divisor\[4\] divisor\[6\] divisor\[5\] VGND VGND VPWR VPWR _0568_ sky130_fd_sc_hd__nor3_1
XFILLER_0_45_3 VPWR VGND VPWR VGND sky130_ef_sc_hd__decap_12
X_2378_ tx_fifo.fifo\[5\]\[7\] net388 _1003_ tx_fifo.fifo\[1\]\[7\] _1004_ tx_fifo.fifo\[14\]\[7\]
+ VGND VGND VPWR VPWR _1176_ sky130_fd_sc_hd__a222oi_1
XFILLER_0_66_438 VGND VGND VPWR VPWR sky130_fd_sc_hd__fill_1
XFILLER_0_66_416 VGND VGND VPWR VPWR sky130_fd_sc_hd__decap_4
XFILLER_0_61_143 VPWR VGND VPWR VGND sky130_ef_sc_hd__decap_12
XFILLER_0_34_379 VGND VGND VPWR VPWR sky130_fd_sc_hd__fill_2
XFILLER_0_19_376 VGND VGND VPWR VPWR sky130_fd_sc_hd__decap_3
Xhold9 regs.tx_data\[0\] VGND VGND VPWR VPWR net270 sky130_fd_sc_hd__dlygate4sd3_1
XFILLER_0_57_449 VGND VGND VPWR VPWR sky130_fd_sc_hd__decap_8
XFILLER_0_25_357 VPWR VGND VPWR VGND sky130_ef_sc_hd__decap_12
XFILLER_0_20_12 VGND VGND VPWR VPWR sky130_fd_sc_hd__decap_4
X_1680_ net114 net158 VGND VGND VPWR VPWR _0210_ sky130_fd_sc_hd__nor2_1
XTAP_725 VGND VPWR sky130_fd_sc_hd__tapvpwrvgnd_1
XTAP_714 VGND VPWR sky130_fd_sc_hd__tapvpwrvgnd_1
XTAP_703 VGND VPWR sky130_fd_sc_hd__tapvpwrvgnd_1
X_2301_ net9 _1136_ VGND VGND VPWR VPWR _1137_ sky130_fd_sc_hd__nor2_1
XTAP_769 VGND VPWR sky130_fd_sc_hd__tapvpwrvgnd_1
XTAP_758 VGND VPWR sky130_fd_sc_hd__tapvpwrvgnd_1
XTAP_747 VGND VPWR sky130_fd_sc_hd__tapvpwrvgnd_1
XTAP_736 VGND VPWR sky130_fd_sc_hd__tapvpwrvgnd_1
Xclkbuf_leaf_2_clk clknet_2_0__leaf_clk VGND VGND VPWR VPWR clknet_leaf_2_clk sky130_fd_sc_hd__clkbuf_16
X_2232_ data_bits\[0\] tx.bit_cnt\[0\] VGND VGND VPWR VPWR _1114_ sky130_fd_sc_hd__xnor2_1
X_2163_ _1050_ _1055_ _1056_ _1057_ VGND VGND VPWR VPWR _1058_ sky130_fd_sc_hd__nand4_1
XFILLER_0_61_30 VGND VGND VPWR VPWR sky130_fd_sc_hd__fill_1
XFILLER_0_48_438 VGND VGND VPWR VPWR sky130_fd_sc_hd__fill_1
X_2094_ net228 net224 net226 net230 VGND VGND VPWR VPWR _0993_ sky130_fd_sc_hd__nor4bb_1
X_2996_ clknet_leaf_11_clk _0363_ net245 VGND VGND VPWR VPWR tx.baud_cnt\[15\] sky130_fd_sc_hd__dfrtp_1
X_1878_ net67 _0893_ VGND VGND VPWR VPWR _0400_ sky130_fd_sc_hd__nor2_1
XFILLER_0_9_53 VGND VGND VPWR VPWR sky130_fd_sc_hd__decap_3
X_1947_ net60 _0903_ VGND VGND VPWR VPWR _0461_ sky130_fd_sc_hd__nor2_1
XFILLER_0_74_290 VGND VGND VPWR VPWR sky130_fd_sc_hd__decap_4
XFILLER_0_54_419 VGND VGND VPWR VPWR sky130_fd_sc_hd__fill_1
XFILLER_0_34_132 VGND VGND VPWR VPWR sky130_fd_sc_hd__decap_8
XFILLER_0_66_19 VGND VGND VPWR VPWR sky130_fd_sc_hd__decap_8
X_2850_ clknet_leaf_6_clk _0142_ net247 VGND VGND VPWR VPWR regs.mcr_reg\[7\] sky130_fd_sc_hd__dfrtp_1
XFILLER_0_15_12 VGND VGND VPWR VPWR sky130_fd_sc_hd__decap_3
XFILLER_0_72_238 VPWR VGND VPWR VGND sky130_ef_sc_hd__decap_12
X_1732_ net102 _0862_ VGND VGND VPWR VPWR _0247_ sky130_fd_sc_hd__nor2_1
X_1801_ _0853_ _0869_ VGND VGND VPWR VPWR _0871_ sky130_fd_sc_hd__nand2_1
X_1663_ rx_fifo.tail\[1\] net233 VGND VGND VPWR VPWR _0853_ sky130_fd_sc_hd__lpflow_isobufsrc_1
X_2781_ clknet_leaf_2_clk _0455_ _0006_ VGND VGND VPWR VPWR tx_fifo.fifo\[5\]\[2\]
+ sky130_fd_sc_hd__edfxtp_1
XFILLER_0_13_316 VPWR VGND VPWR VGND sky130_ef_sc_hd__decap_12
XFILLER_0_13_349 VGND VGND VPWR VPWR sky130_fd_sc_hd__decap_3
X_1594_ net237 regs.dlh\[2\] VGND VGND VPWR VPWR _0799_ sky130_fd_sc_hd__nand2_1
XTAP_566 VGND VPWR sky130_fd_sc_hd__tapvpwrvgnd_1
XTAP_555 VGND VPWR sky130_fd_sc_hd__tapvpwrvgnd_1
XTAP_544 VGND VPWR sky130_fd_sc_hd__tapvpwrvgnd_1
XTAP_533 VGND VPWR sky130_fd_sc_hd__tapvpwrvgnd_1
XTAP_522 VGND VPWR sky130_fd_sc_hd__tapvpwrvgnd_1
XTAP_511 VGND VPWR sky130_fd_sc_hd__tapvpwrvgnd_1
XTAP_500 VGND VPWR sky130_fd_sc_hd__tapvpwrvgnd_1
XFILLER_0_0_221 VGND VGND VPWR VPWR sky130_fd_sc_hd__decap_3
XFILLER_0_0_265 VPWR VGND VPWR VGND sky130_ef_sc_hd__decap_12
XFILLER_0_0_287 VPWR VGND VPWR VGND sky130_ef_sc_hd__decap_12
XFILLER_0_56_85 VGND VGND VPWR VPWR sky130_fd_sc_hd__decap_8
XFILLER_0_56_63 VGND VGND VPWR VPWR sky130_fd_sc_hd__fill_1
XTAP_599 VGND VPWR sky130_fd_sc_hd__tapvpwrvgnd_1
XTAP_588 VGND VPWR sky130_fd_sc_hd__tapvpwrvgnd_1
XTAP_577 VGND VPWR sky130_fd_sc_hd__tapvpwrvgnd_1
X_2215_ rx_fifo.count\[2\] _1092_ VGND VGND VPWR VPWR _1100_ sky130_fd_sc_hd__nand2_1
X_2146_ tx_fifo.fifo\[11\]\[3\] _1005_ _1009_ tx_fifo.fifo\[15\]\[3\] _1041_ VGND
+ VGND VPWR VPWR _1042_ sky130_fd_sc_hd__a221oi_1
X_2077_ _0938_ _0944_ _0961_ VGND VGND VPWR VPWR _0985_ sky130_fd_sc_hd__nand3_1
XFILLER_0_63_205 VGND VGND VPWR VPWR sky130_fd_sc_hd__decap_8
X_2979_ clknet_leaf_7_clk net293 net243 VGND VGND VPWR VPWR rx.baud_cnt\[14\] sky130_fd_sc_hd__dfrtp_1
XFILLER_0_8_365 VGND VGND VPWR VPWR sky130_fd_sc_hd__decap_6
XFILLER_0_71_293 VGND VGND VPWR VPWR sky130_fd_sc_hd__fill_2
XFILLER_0_77_29 VPWR VGND VPWR VGND sky130_ef_sc_hd__decap_12
XFILLER_0_26_33 VGND VGND VPWR VPWR sky130_fd_sc_hd__fill_1
X_2000_ tx_fifo.count\[1\] tx_fifo.count\[0\] VGND VGND VPWR VPWR _0922_ sky130_fd_sc_hd__nand2_1
XFILLER_0_42_76 VGND VGND VPWR VPWR sky130_fd_sc_hd__decap_8
X_2902_ clknet_leaf_29_clk _0071_ net260 VGND VGND VPWR VPWR rx_fifo.head\[1\] sky130_fd_sc_hd__dfrtp_4
X_2833_ clknet_leaf_41_clk _0419_ net56 VGND VGND VPWR VPWR tx_fifo.fifo\[10\]\[6\]
+ sky130_fd_sc_hd__edfxtp_1
XFILLER_0_53_271 VGND VGND VPWR VPWR sky130_fd_sc_hd__decap_8
X_1646_ _0841_ net117 VGND VGND VPWR VPWR _0190_ sky130_fd_sc_hd__nor2_1
X_1715_ net113 net155 VGND VGND VPWR VPWR _0243_ sky130_fd_sc_hd__nor2_1
X_2695_ clknet_leaf_28_clk _0240_ net92 VGND VGND VPWR VPWR rx_fifo.fifo\[10\]\[3\]
+ sky130_fd_sc_hd__edfxtp_1
X_2764_ clknet_leaf_0_clk _0462_ net44 VGND VGND VPWR VPWR tx_fifo.fifo\[4\]\[1\]
+ sky130_fd_sc_hd__edfxtp_1
X_1577_ _0714_ _0777_ _0782_ VGND VGND VPWR VPWR _0783_ sky130_fd_sc_hd__o21ai_0
XTAP_396 VGND VPWR sky130_fd_sc_hd__tapvpwrvgnd_1
XTAP_385 VGND VPWR sky130_fd_sc_hd__tapvpwrvgnd_1
XTAP_374 VGND VPWR sky130_fd_sc_hd__tapvpwrvgnd_1
XTAP_363 VGND VPWR sky130_fd_sc_hd__tapvpwrvgnd_1
XTAP_352 VGND VPWR sky130_fd_sc_hd__tapvpwrvgnd_1
XTAP_341 VGND VPWR sky130_fd_sc_hd__tapvpwrvgnd_1
XFILLER_0_6_65 VPWR VGND VPWR VGND sky130_ef_sc_hd__decap_12
XTAP_330 VGND VPWR sky130_fd_sc_hd__tapvpwrvgnd_1
XPHY_69 VGND VGND VPWR VPWR sky130_fd_sc_hd__decap_3
XPHY_58 VGND VGND VPWR VPWR sky130_fd_sc_hd__decap_3
XPHY_47 VGND VGND VPWR VPWR sky130_fd_sc_hd__decap_3
XPHY_14 VGND VGND VPWR VPWR sky130_fd_sc_hd__decap_3
X_2129_ tx_fifo.fifo\[3\]\[5\] net194 net187 tx_fifo.fifo\[6\]\[5\] _1026_ VGND VGND
+ VPWR VPWR _1027_ sky130_fd_sc_hd__a221oi_2
XPHY_25 VGND VGND VPWR VPWR sky130_fd_sc_hd__decap_3
XPHY_36 VGND VGND VPWR VPWR sky130_fd_sc_hd__decap_3
XFILLER_0_32_433 VGND VGND VPWR VPWR sky130_fd_sc_hd__decap_4
XFILLER_0_32_400 VPWR VGND VPWR VGND sky130_ef_sc_hd__decap_12
XFILLER_0_8_195 VGND VGND VPWR VPWR sky130_fd_sc_hd__fill_1
XFILLER_0_4_390 VPWR VGND VPWR VGND sky130_ef_sc_hd__decap_12
X_1500_ _0652_ net74 _0711_ VGND VGND VPWR VPWR _0169_ sky130_fd_sc_hd__nor3_1
XFILLER_0_42_208 VGND VGND VPWR VPWR sky130_fd_sc_hd__decap_6
XFILLER_0_23_455 VGND VGND VPWR VPWR sky130_fd_sc_hd__decap_8
X_2480_ rx.shift_reg\[4\] rx.shift_reg\[5\] VGND VGND VPWR VPWR _1227_ sky130_fd_sc_hd__xor2_1
X_1362_ divisor\[4\] _0567_ VGND VGND VPWR VPWR _0601_ sky130_fd_sc_hd__xnor2_1
X_1431_ rx.baud_cnt\[7\] _0654_ VGND VGND VPWR VPWR _0655_ sky130_fd_sc_hd__and2_1
X_1293_ _0517_ _0519_ VGND VGND VPWR VPWR _0535_ sky130_fd_sc_hd__nor2_2
XFILLER_0_53_42 VGND VGND VPWR VPWR sky130_fd_sc_hd__decap_8
XFILLER_0_58_363 VGND VGND VPWR VPWR sky130_fd_sc_hd__fill_1
X_2816_ clknet_leaf_38_clk _0434_ net38 VGND VGND VPWR VPWR tx_fifo.fifo\[8\]\[5\]
+ sky130_fd_sc_hd__edfxtp_1
XFILLER_0_75_3 VPWR VGND VPWR VGND sky130_ef_sc_hd__decap_12
X_1629_ rx_fifo.fifo\[7\]\[0\] net172 net164 rx_fifo.fifo\[15\]\[0\] VGND VGND VPWR
+ VPWR _0831_ sky130_fd_sc_hd__a22oi_1
X_2678_ clknet_leaf_5_clk _0267_ net95 VGND VGND VPWR VPWR rx_fifo.fifo\[8\]\[8\]
+ sky130_fd_sc_hd__edfxtp_1
XFILLER_0_1_393 VPWR VGND VPWR VGND sky130_ef_sc_hd__decap_12
X_2747_ clknet_leaf_1_clk _0397_ _0010_ VGND VGND VPWR VPWR tx_fifo.fifo\[12\]\[0\]
+ sky130_fd_sc_hd__edfxtp_1
XTAP_193 VGND VPWR sky130_fd_sc_hd__tapvpwrvgnd_1
XTAP_182 VGND VPWR sky130_fd_sc_hd__tapvpwrvgnd_1
XTAP_171 VGND VPWR sky130_fd_sc_hd__tapvpwrvgnd_1
XTAP_160 VGND VPWR sky130_fd_sc_hd__tapvpwrvgnd_1
XFILLER_0_68_149 VPWR VGND VPWR VGND sky130_ef_sc_hd__decap_12
XFILLER_0_68_105 VGND VGND VPWR VPWR sky130_fd_sc_hd__fill_1
XFILLER_0_64_388 VGND VGND VPWR VPWR sky130_fd_sc_hd__fill_1
XFILLER_0_74_19 VGND VGND VPWR VPWR sky130_fd_sc_hd__decap_8
XFILLER_0_20_436 VGND VGND VPWR VPWR sky130_fd_sc_hd__decap_6
XFILLER_0_59_138 VGND VGND VPWR VPWR sky130_fd_sc_hd__decap_8
XFILLER_0_23_12 VGND VGND VPWR VPWR sky130_fd_sc_hd__decap_6
XFILLER_0_55_377 VGND VGND VPWR VPWR sky130_fd_sc_hd__fill_1
XFILLER_0_55_333 VGND VGND VPWR VPWR sky130_fd_sc_hd__decap_3
XFILLER_0_55_311 VGND VGND VPWR VPWR sky130_fd_sc_hd__decap_6
X_1980_ net61 _0908_ VGND VGND VPWR VPWR _0493_ sky130_fd_sc_hd__nor2_1
X_2532_ clknet_leaf_18_clk _0198_ net86 VGND VGND VPWR VPWR rx_fifo.fifo\[14\]\[5\]
+ sky130_fd_sc_hd__edfxtp_1
X_2601_ clknet_leaf_26_clk _0322_ net81 VGND VGND VPWR VPWR rx_fifo.fifo\[3\]\[8\]
+ sky130_fd_sc_hd__edfxtp_1
X_2463_ net332 _1196_ VGND VGND VPWR VPWR _1221_ sky130_fd_sc_hd__nand2_1
XFILLER_0_23_241 VGND VGND VPWR VPWR sky130_fd_sc_hd__fill_1
X_1414_ net52 _0633_ _0645_ VGND VGND VPWR VPWR _0370_ sky130_fd_sc_hd__nor3_1
X_1345_ divisor\[15\] divisor\[14\] _0578_ VGND VGND VPWR VPWR _0584_ sky130_fd_sc_hd__nor3_1
X_1276_ rx_fifo.head\[3\] rx_fifo.head\[2\] _0517_ VGND VGND VPWR VPWR _0518_ sky130_fd_sc_hd__nor3_1
X_2394_ rx.break_int net125 VGND VGND VPWR VPWR _1191_ sky130_fd_sc_hd__nand2_1
Xwire78 _0627_ VGND VGND VPWR VPWR net78 sky130_fd_sc_hd__buf_1
XFILLER_0_64_85 VGND VGND VPWR VPWR sky130_fd_sc_hd__fill_1
XFILLER_0_58_193 VGND VGND VPWR VPWR sky130_fd_sc_hd__decap_3
Xfanout165 _0534_ VGND VGND VPWR VPWR net165 sky130_fd_sc_hd__buf_4
Xfanout154 _0862_ VGND VGND VPWR VPWR net154 sky130_fd_sc_hd__clkbuf_4
Xfanout110 _0848_ VGND VGND VPWR VPWR net110 sky130_fd_sc_hd__buf_2
XFILLER_0_69_447 VGND VGND VPWR VPWR sky130_fd_sc_hd__fill_1
Xfanout176 _0518_ VGND VGND VPWR VPWR net176 sky130_fd_sc_hd__clkbuf_4
XFILLER_0_64_185 VGND VGND VPWR VPWR sky130_fd_sc_hd__fill_1
XFILLER_0_52_303 VGND VGND VPWR VPWR sky130_fd_sc_hd__fill_2
XFILLER_0_37_377 VGND VGND VPWR VPWR sky130_fd_sc_hd__decap_6
XFILLER_0_47_119 VGND VGND VPWR VPWR sky130_fd_sc_hd__fill_1
XFILLER_0_34_77 VGND VGND VPWR VPWR sky130_fd_sc_hd__decap_6
XFILLER_0_70_166 VGND VGND VPWR VPWR sky130_fd_sc_hd__fill_2
XFILLER_0_50_98 VGND VGND VPWR VPWR sky130_fd_sc_hd__decap_6
XFILLER_0_50_54 VGND VGND VPWR VPWR sky130_fd_sc_hd__fill_1
X_1894_ net68 _0896_ VGND VGND VPWR VPWR _0417_ sky130_fd_sc_hd__nor2_1
X_1963_ net62 _0906_ VGND VGND VPWR VPWR _0478_ sky130_fd_sc_hd__nor2_1
X_2515_ net52 _1248_ _1249_ VGND VGND VPWR VPWR _0363_ sky130_fd_sc_hd__nor3_1
X_2446_ rx_fifo.fifo\[13\]\[7\] _0521_ VGND VGND VPWR VPWR _1208_ sky130_fd_sc_hd__nand2_1
XFILLER_0_75_51 VGND VGND VPWR VPWR sky130_fd_sc_hd__decap_4
X_1328_ divisor\[2\] divisor\[0\] divisor\[3\] divisor\[1\] VGND VGND VPWR VPWR _0567_
+ sky130_fd_sc_hd__or4_4
X_2377_ tx_fifo.fifo\[0\]\[7\] net386 VGND VGND VPWR VPWR _1175_ sky130_fd_sc_hd__nand2_1
X_1259_ rx.bit_cnt\[1\] VGND VGND VPWR VPWR _0504_ sky130_fd_sc_hd__inv_1
XFILLER_0_61_111 VGND VGND VPWR VPWR sky130_fd_sc_hd__fill_1
XFILLER_0_46_141 VGND VGND VPWR VPWR sky130_fd_sc_hd__decap_8
XFILLER_0_61_177 VGND VGND VPWR VPWR sky130_fd_sc_hd__fill_2
XFILLER_0_61_166 VGND VGND VPWR VPWR sky130_fd_sc_hd__fill_2
XFILLER_0_61_155 VGND VGND VPWR VPWR sky130_fd_sc_hd__decap_6
XFILLER_0_42_380 VPWR VGND VPWR VGND sky130_ef_sc_hd__decap_12
XFILLER_0_69_266 VGND VGND VPWR VPWR sky130_fd_sc_hd__decap_4
XFILLER_0_25_369 VGND VGND VPWR VPWR sky130_fd_sc_hd__fill_1
XTAP_759 VGND VPWR sky130_fd_sc_hd__tapvpwrvgnd_1
XTAP_748 VGND VPWR sky130_fd_sc_hd__tapvpwrvgnd_1
XTAP_737 VGND VPWR sky130_fd_sc_hd__tapvpwrvgnd_1
XTAP_726 VGND VPWR sky130_fd_sc_hd__tapvpwrvgnd_1
XTAP_715 VGND VPWR sky130_fd_sc_hd__tapvpwrvgnd_1
XTAP_704 VGND VPWR sky130_fd_sc_hd__tapvpwrvgnd_1
X_2300_ net239 net181 VGND VGND VPWR VPWR _1136_ sky130_fd_sc_hd__nand2_2
XFILLER_0_0_436 VPWR VGND VPWR VGND sky130_ef_sc_hd__decap_12
X_2231_ tx.state\[0\] tx.state\[2\] VGND VGND VPWR VPWR _1113_ sky130_fd_sc_hd__lpflow_isobufsrc_1
X_2093_ net212 _0912_ _0991_ VGND VGND VPWR VPWR _0992_ sky130_fd_sc_hd__a21oi_4
X_2162_ tx_fifo.fifo\[7\]\[2\] _0996_ net193 tx_fifo.fifo\[3\]\[2\] VGND VGND VPWR
+ VPWR _1057_ sky130_fd_sc_hd__a22oi_1
X_2995_ clknet_leaf_11_clk _0362_ net244 VGND VGND VPWR VPWR tx.baud_cnt\[14\] sky130_fd_sc_hd__dfrtp_2
XFILLER_0_61_75 VGND VGND VPWR VPWR sky130_fd_sc_hd__fill_2
XFILLER_0_28_141 VPWR VGND VPWR VGND sky130_ef_sc_hd__decap_12
XFILLER_0_43_188 VPWR VGND VPWR VGND sky130_ef_sc_hd__decap_12
XFILLER_0_43_111 VGND VGND VPWR VPWR sky130_fd_sc_hd__fill_1
X_1946_ net62 _0903_ VGND VGND VPWR VPWR _0462_ sky130_fd_sc_hd__nor2_1
X_1877_ net69 _0893_ VGND VGND VPWR VPWR _0401_ sky130_fd_sc_hd__nor2_1
X_2429_ rx_fifo.tail\[2\] _0840_ rx_fifo.tail\[3\] VGND VGND VPWR VPWR _1201_ sky130_fd_sc_hd__a21oi_1
XFILLER_0_62_431 VGND VGND VPWR VPWR sky130_fd_sc_hd__fill_1
XFILLER_0_47_461 VGND VGND VPWR VPWR sky130_fd_sc_hd__fill_2
X_1800_ net102 net148 VGND VGND VPWR VPWR _0313_ sky130_fd_sc_hd__nor2_1
XFILLER_0_57_225 VGND VGND VPWR VPWR sky130_fd_sc_hd__decap_8
XFILLER_0_31_12 VGND VGND VPWR VPWR sky130_fd_sc_hd__decap_4
XFILLER_0_15_57 VGND VGND VPWR VPWR sky130_fd_sc_hd__decap_3
X_1662_ _0841_ net102 VGND VGND VPWR VPWR _0181_ sky130_fd_sc_hd__nor2_1
X_1731_ net103 net154 VGND VGND VPWR VPWR _0249_ sky130_fd_sc_hd__nor2_1
XFILLER_0_40_136 VGND VGND VPWR VPWR sky130_fd_sc_hd__decap_4
X_2780_ clknet_leaf_2_clk _0454_ net42 VGND VGND VPWR VPWR tx_fifo.fifo\[5\]\[1\]
+ sky130_fd_sc_hd__edfxtp_1
XFILLER_0_25_155 VGND VGND VPWR VPWR sky130_fd_sc_hd__decap_4
XFILLER_0_13_328 VGND VGND VPWR VPWR sky130_fd_sc_hd__decap_8
XTAP_589 VGND VPWR sky130_fd_sc_hd__tapvpwrvgnd_1
XTAP_578 VGND VPWR sky130_fd_sc_hd__tapvpwrvgnd_1
X_1593_ net211 _0797_ VGND VGND VPWR VPWR _0798_ sky130_fd_sc_hd__nand2_1
XTAP_567 VGND VPWR sky130_fd_sc_hd__tapvpwrvgnd_1
XTAP_556 VGND VPWR sky130_fd_sc_hd__tapvpwrvgnd_1
XTAP_545 VGND VPWR sky130_fd_sc_hd__tapvpwrvgnd_1
XTAP_534 VGND VPWR sky130_fd_sc_hd__tapvpwrvgnd_1
XTAP_523 VGND VPWR sky130_fd_sc_hd__tapvpwrvgnd_1
XTAP_512 VGND VPWR sky130_fd_sc_hd__tapvpwrvgnd_1
XTAP_501 VGND VPWR sky130_fd_sc_hd__tapvpwrvgnd_1
X_2214_ _1093_ _1095_ _1099_ net222 VGND VGND VPWR VPWR _0073_ sky130_fd_sc_hd__a31oi_1
XFILLER_0_21_350 VPWR VGND VPWR VGND sky130_ef_sc_hd__decap_12
XFILLER_0_0_277 VGND VGND VPWR VPWR sky130_fd_sc_hd__decap_3
XFILLER_0_0_299 VGND VGND VPWR VPWR sky130_fd_sc_hd__decap_8
XFILLER_0_72_41 VPWR VGND VPWR VGND sky130_ef_sc_hd__decap_12
XFILLER_0_56_75 VGND VGND VPWR VPWR sky130_fd_sc_hd__decap_8
X_2145_ tx_fifo.fifo\[10\]\[3\] net195 _1001_ tx_fifo.fifo\[9\]\[3\] VGND VGND VPWR
+ VPWR _1041_ sky130_fd_sc_hd__a22o_1
X_2076_ _0979_ _0982_ _0983_ VGND VGND VPWR VPWR _0984_ sky130_fd_sc_hd__and3_1
X_2978_ clknet_leaf_8_clk _0165_ net243 VGND VGND VPWR VPWR rx.baud_cnt\[13\] sky130_fd_sc_hd__dfrtp_1
X_1929_ net64 _0901_ VGND VGND VPWR VPWR _0447_ sky130_fd_sc_hd__nor2_1
XFILLER_0_31_169 VGND VGND VPWR VPWR sky130_fd_sc_hd__decap_6
XFILLER_0_54_206 VGND VGND VPWR VPWR sky130_fd_sc_hd__decap_4
XFILLER_0_39_225 VGND VGND VPWR VPWR sky130_fd_sc_hd__decap_4
XFILLER_0_62_283 VGND VGND VPWR VPWR sky130_fd_sc_hd__decap_8
XFILLER_0_47_291 VPWR VGND VPWR VGND sky130_ef_sc_hd__decap_12
XFILLER_0_77_309 VPWR VGND VPWR VGND sky130_ef_sc_hd__decap_12
Xhold90 rx.shift_reg\[5\] VGND VGND VPWR VPWR net351 sky130_fd_sc_hd__dlygate4sd3_1
X_2901_ clknet_leaf_29_clk _0072_ net259 VGND VGND VPWR VPWR rx_fifo.head\[0\] sky130_fd_sc_hd__dfrtp_4
X_2832_ clknet_leaf_41_clk _0418_ net380 VGND VGND VPWR VPWR tx_fifo.fifo\[10\]\[5\]
+ sky130_fd_sc_hd__edfxtp_1
X_2763_ clknet_leaf_1_clk _0461_ _0008_ VGND VGND VPWR VPWR tx_fifo.fifo\[4\]\[0\]
+ sky130_fd_sc_hd__edfxtp_1
X_1576_ parity_en _0734_ _0781_ VGND VGND VPWR VPWR _0782_ sky130_fd_sc_hd__a21oi_1
X_2694_ clknet_leaf_38_clk _0239_ net92 VGND VGND VPWR VPWR rx_fifo.fifo\[10\]\[2\]
+ sky130_fd_sc_hd__edfxtp_1
X_1714_ net115 net155 VGND VGND VPWR VPWR _0244_ sky130_fd_sc_hd__nor2_1
X_1645_ rx.parity_err net126 VGND VGND VPWR VPWR _0844_ sky130_fd_sc_hd__nand2_1
XFILLER_0_5_369 VGND VGND VPWR VPWR sky130_fd_sc_hd__fill_2
XFILLER_0_13_169 VGND VGND VPWR VPWR sky130_fd_sc_hd__decap_8
XTAP_397 VGND VPWR sky130_fd_sc_hd__tapvpwrvgnd_1
XTAP_386 VGND VPWR sky130_fd_sc_hd__tapvpwrvgnd_1
XTAP_375 VGND VPWR sky130_fd_sc_hd__tapvpwrvgnd_1
XTAP_364 VGND VPWR sky130_fd_sc_hd__tapvpwrvgnd_1
XTAP_353 VGND VPWR sky130_fd_sc_hd__tapvpwrvgnd_1
XTAP_342 VGND VPWR sky130_fd_sc_hd__tapvpwrvgnd_1
XFILLER_0_6_77 VGND VGND VPWR VPWR sky130_fd_sc_hd__decap_6
XFILLER_0_20_3 VGND VGND VPWR VPWR sky130_fd_sc_hd__decap_6
XTAP_320 VGND VPWR sky130_fd_sc_hd__tapvpwrvgnd_1
XTAP_331 VGND VPWR sky130_fd_sc_hd__tapvpwrvgnd_1
XFILLER_0_36_206 VGND VGND VPWR VPWR sky130_fd_sc_hd__decap_4
XPHY_59 VGND VGND VPWR VPWR sky130_fd_sc_hd__decap_3
XPHY_48 VGND VGND VPWR VPWR sky130_fd_sc_hd__decap_3
X_2128_ _1021_ _1022_ _1024_ net143 VGND VGND VPWR VPWR _1026_ sky130_fd_sc_hd__nand4_1
XPHY_15 VGND VGND VPWR VPWR sky130_fd_sc_hd__decap_3
X_2059_ rx.state\[1\] net232 rx.state\[0\] VGND VGND VPWR VPWR _0968_ sky130_fd_sc_hd__nor3b_1
XPHY_26 VGND VGND VPWR VPWR sky130_fd_sc_hd__decap_3
XPHY_37 VGND VGND VPWR VPWR sky130_fd_sc_hd__decap_3
XFILLER_0_44_294 VGND VGND VPWR VPWR sky130_fd_sc_hd__decap_3
XFILLER_0_44_272 VPWR VGND VPWR VGND sky130_ef_sc_hd__decap_12
XFILLER_0_44_261 VGND VGND VPWR VPWR sky130_fd_sc_hd__decap_3
XFILLER_0_32_412 VGND VGND VPWR VPWR sky130_fd_sc_hd__decap_8
XFILLER_0_8_141 VGND VGND VPWR VPWR sky130_fd_sc_hd__decap_6
X_1430_ rx.baud_cnt\[6\] rx.baud_cnt\[5\] _0653_ VGND VGND VPWR VPWR _0654_ sky130_fd_sc_hd__and3_1
XFILLER_0_50_231 VPWR VGND VPWR VGND sky130_ef_sc_hd__decap_12
XFILLER_0_2_306 VGND VGND VPWR VPWR sky130_fd_sc_hd__fill_2
XFILLER_0_10_139 VGND VGND VPWR VPWR sky130_fd_sc_hd__fill_1
X_1361_ _0589_ _0599_ VGND VGND VPWR VPWR _0600_ sky130_fd_sc_hd__nor2_1
X_1292_ rx_fifo.head\[0\] rx_fifo.head\[1\] _0519_ VGND VGND VPWR VPWR _0534_ sky130_fd_sc_hd__nor3_2
XFILLER_0_37_55 VGND VGND VPWR VPWR sky130_fd_sc_hd__fill_1
XFILLER_0_77_139 VGND VGND VPWR VPWR sky130_fd_sc_hd__fill_1
XFILLER_0_77_128 VGND VGND VPWR VPWR sky130_fd_sc_hd__fill_1
XFILLER_0_73_389 VGND VGND VPWR VPWR sky130_fd_sc_hd__decap_3
XFILLER_0_58_397 VGND VGND VPWR VPWR sky130_fd_sc_hd__decap_6
X_2815_ clknet_leaf_4_clk _0433_ _0002_ VGND VGND VPWR VPWR tx_fifo.fifo\[8\]\[4\]
+ sky130_fd_sc_hd__edfxtp_1
XFILLER_0_5_177 VGND VGND VPWR VPWR sky130_fd_sc_hd__decap_3
XFILLER_0_14_445 VGND VGND VPWR VPWR sky130_fd_sc_hd__decap_8
X_2746_ clknet_leaf_0_clk _0484_ _0011_ VGND VGND VPWR VPWR tx_fifo.fifo\[2\]\[7\]
+ sky130_fd_sc_hd__edfxtp_1
XFILLER_0_68_3 VPWR VGND VPWR VGND sky130_ef_sc_hd__decap_12
X_1628_ rx_fifo.fifo\[3\]\[0\] net176 net168 rx_fifo.fifo\[1\]\[0\] _0538_ rx_fifo.fifo\[9\]\[0\]
+ VGND VGND VPWR VPWR _0830_ sky130_fd_sc_hd__a222oi_1
X_1559_ parity_type _0734_ _0765_ VGND VGND VPWR VPWR _0766_ sky130_fd_sc_hd__a21oi_1
X_2677_ clknet_leaf_27_clk _0266_ net95 VGND VGND VPWR VPWR rx_fifo.fifo\[8\]\[7\]
+ sky130_fd_sc_hd__edfxtp_1
XTAP_194 VGND VPWR sky130_fd_sc_hd__tapvpwrvgnd_1
XTAP_183 VGND VPWR sky130_fd_sc_hd__tapvpwrvgnd_1
XTAP_172 VGND VPWR sky130_fd_sc_hd__tapvpwrvgnd_1
XTAP_161 VGND VPWR sky130_fd_sc_hd__tapvpwrvgnd_1
XFILLER_0_49_375 VPWR VGND VPWR VGND sky130_ef_sc_hd__decap_12
XFILLER_0_49_364 VGND VGND VPWR VPWR sky130_fd_sc_hd__fill_2
XFILLER_0_9_461 VGND VGND VPWR VPWR sky130_fd_sc_hd__fill_2
XFILLER_0_32_253 VPWR VGND VPWR VGND sky130_ef_sc_hd__decap_12
XFILLER_0_67_161 VGND VGND VPWR VPWR sky130_fd_sc_hd__decap_6
XFILLER_0_59_117 VGND VGND VPWR VPWR sky130_fd_sc_hd__fill_1
X_2600_ clknet_leaf_20_clk _0321_ net81 VGND VGND VPWR VPWR rx_fifo.fifo\[3\]\[7\]
+ sky130_fd_sc_hd__edfxtp_1
XFILLER_0_55_323 VGND VGND VPWR VPWR sky130_fd_sc_hd__decap_4
XFILLER_0_23_57 VGND VGND VPWR VPWR sky130_fd_sc_hd__fill_2
X_1413_ net372 _0632_ VGND VGND VPWR VPWR _0645_ sky130_fd_sc_hd__nor2_1
X_2531_ clknet_leaf_20_clk _0197_ net86 VGND VGND VPWR VPWR rx_fifo.fifo\[14\]\[4\]
+ sky130_fd_sc_hd__edfxtp_1
X_2462_ _0898_ net55 VGND VGND VPWR VPWR _0436_ sky130_fd_sc_hd__nor2_1
XFILLER_0_2_147 VGND VGND VPWR VPWR sky130_fd_sc_hd__fill_1
X_2393_ net75 _1189_ _1190_ VGND VGND VPWR VPWR _0131_ sky130_fd_sc_hd__o21ai_0
X_1344_ tx.baud_cnt\[13\] _0582_ VGND VGND VPWR VPWR _0583_ sky130_fd_sc_hd__xnor2_1
X_1275_ rx_fifo.head\[0\] rx_fifo.head\[1\] VGND VGND VPWR VPWR _0517_ sky130_fd_sc_hd__nand2_2
Xwire79 _0622_ VGND VGND VPWR VPWR net79 sky130_fd_sc_hd__buf_1
XFILLER_0_61_337 VPWR VGND VPWR VGND sky130_ef_sc_hd__decap_12
X_2729_ clknet_leaf_4_clk _0499_ net49 VGND VGND VPWR VPWR tx_fifo.fifo\[0\]\[6\]
+ sky130_fd_sc_hd__edfxtp_1
XFILLER_0_14_253 VGND VGND VPWR VPWR sky130_fd_sc_hd__decap_4
XFILLER_0_14_297 VGND VGND VPWR VPWR sky130_fd_sc_hd__decap_8
Xfanout111 net112 VGND VGND VPWR VPWR net111 sky130_fd_sc_hd__clkbuf_4
Xfanout166 _0533_ VGND VGND VPWR VPWR net166 sky130_fd_sc_hd__clkbuf_4
Xfanout100 _0023_ VGND VGND VPWR VPWR net100 sky130_fd_sc_hd__buf_4
Xfanout155 _0861_ VGND VGND VPWR VPWR net155 sky130_fd_sc_hd__clkbuf_4
XFILLER_0_49_183 VGND VGND VPWR VPWR sky130_fd_sc_hd__fill_2
XFILLER_0_49_161 VGND VGND VPWR VPWR sky130_fd_sc_hd__fill_2
XFILLER_0_34_23 VGND VGND VPWR VPWR sky130_fd_sc_hd__fill_2
X_1962_ net64 _0906_ VGND VGND VPWR VPWR _0479_ sky130_fd_sc_hd__nor2_1
XFILLER_0_55_175 VGND VGND VPWR VPWR sky130_fd_sc_hd__fill_1
XFILLER_0_51_381 VGND VGND VPWR VPWR sky130_fd_sc_hd__decap_8
XFILLER_0_28_389 VGND VGND VPWR VPWR sky130_fd_sc_hd__fill_1
X_1893_ net70 _0896_ VGND VGND VPWR VPWR _0418_ sky130_fd_sc_hd__nor2_1
XFILLER_0_11_223 VGND VGND VPWR VPWR sky130_fd_sc_hd__fill_1
X_2514_ tx.baud_cnt\[15\] tx.baud_cnt\[14\] _0637_ VGND VGND VPWR VPWR _1249_ sky130_fd_sc_hd__and3_1
X_2445_ divisor\[7\] net236 VGND VGND VPWR VPWR _1207_ sky130_fd_sc_hd__nand2_1
XFILLER_0_11_289 VGND VGND VPWR VPWR sky130_fd_sc_hd__fill_1
X_2376_ _1171_ _1172_ _1173_ VGND VGND VPWR VPWR _1174_ sky130_fd_sc_hd__o21a_1
X_1327_ divisor\[3\] _0565_ VGND VGND VPWR VPWR _0566_ sky130_fd_sc_hd__nor2_1
X_1258_ rx.baud_cnt\[11\] VGND VGND VPWR VPWR _0503_ sky130_fd_sc_hd__inv_1
XFILLER_0_38_109 VGND VGND VPWR VPWR sky130_fd_sc_hd__fill_2
XFILLER_0_61_101 VGND VGND VPWR VPWR sky130_fd_sc_hd__decap_6
XFILLER_0_34_348 VGND VGND VPWR VPWR sky130_fd_sc_hd__fill_1
XFILLER_0_6_261 VPWR VGND VPWR VGND sky130_ef_sc_hd__decap_12
XFILLER_0_42_392 VGND VGND VPWR VPWR sky130_fd_sc_hd__decap_3
XFILLER_0_69_278 VGND VGND VPWR VPWR sky130_fd_sc_hd__fill_2
XFILLER_0_40_307 VGND VGND VPWR VPWR sky130_fd_sc_hd__fill_1
XFILLER_0_25_326 VGND VGND VPWR VPWR sky130_fd_sc_hd__fill_1
XTAP_749 VGND VPWR sky130_fd_sc_hd__tapvpwrvgnd_1
XTAP_738 VGND VPWR sky130_fd_sc_hd__tapvpwrvgnd_1
XTAP_727 VGND VPWR sky130_fd_sc_hd__tapvpwrvgnd_1
XTAP_716 VGND VPWR sky130_fd_sc_hd__tapvpwrvgnd_1
XTAP_705 VGND VPWR sky130_fd_sc_hd__tapvpwrvgnd_1
X_2230_ _0628_ _1111_ _1109_ VGND VGND VPWR VPWR _1112_ sky130_fd_sc_hd__o21ai_2
XFILLER_0_45_55 VGND VGND VPWR VPWR sky130_fd_sc_hd__fill_1
X_2161_ tx_fifo.fifo\[8\]\[2\] _1002_ net190 tx_fifo.fifo\[1\]\[2\] VGND VGND VPWR
+ VPWR _1056_ sky130_fd_sc_hd__a22oi_1
XFILLER_0_0_13 VPWR VGND VPWR VGND sky130_ef_sc_hd__decap_12
X_2092_ _0628_ _0990_ VGND VGND VPWR VPWR _0991_ sky130_fd_sc_hd__nor2_4
X_2994_ clknet_leaf_11_clk _0361_ net244 VGND VGND VPWR VPWR tx.baud_cnt\[13\] sky130_fd_sc_hd__dfrtp_1
XFILLER_0_61_43 VGND VGND VPWR VPWR sky130_fd_sc_hd__decap_6
XFILLER_0_56_462 VGND VGND VPWR VPWR sky130_fd_sc_hd__fill_1
XFILLER_0_28_197 VGND VGND VPWR VPWR sky130_fd_sc_hd__decap_4
XFILLER_0_28_153 VPWR VGND VPWR VGND sky130_ef_sc_hd__decap_12
XFILLER_0_0_57 VPWR VGND VPWR VGND sky130_ef_sc_hd__decap_12
X_1945_ net64 _0903_ VGND VGND VPWR VPWR _0463_ sky130_fd_sc_hd__nor2_1
X_1876_ net70 _0893_ VGND VGND VPWR VPWR _0402_ sky130_fd_sc_hd__nor2_1
XFILLER_0_9_99 VPWR VGND VPWR VGND sky130_ef_sc_hd__decap_12
XFILLER_0_50_3 VGND VGND VPWR VPWR sky130_fd_sc_hd__decap_4
X_2428_ net371 net234 _1086_ _1200_ net222 VGND VGND VPWR VPWR _0136_ sky130_fd_sc_hd__a311oi_1
X_2359_ net219 _0903_ net58 VGND VGND VPWR VPWR _0008_ sky130_fd_sc_hd__nor3_1
XFILLER_0_66_248 VGND VGND VPWR VPWR sky130_fd_sc_hd__decap_4
XFILLER_0_62_421 VGND VGND VPWR VPWR sky130_fd_sc_hd__fill_2
XFILLER_0_22_318 VGND VGND VPWR VPWR sky130_fd_sc_hd__decap_6
XFILLER_0_19_197 VGND VGND VPWR VPWR sky130_fd_sc_hd__decap_4
XFILLER_0_65_281 VGND VGND VPWR VPWR sky130_fd_sc_hd__decap_8
XFILLER_0_57_215 VGND VGND VPWR VPWR sky130_fd_sc_hd__fill_1
XFILLER_0_57_204 VGND VGND VPWR VPWR sky130_fd_sc_hd__decap_4
XFILLER_0_31_57 VGND VGND VPWR VPWR sky130_fd_sc_hd__fill_1
XFILLER_0_25_123 VGND VGND VPWR VPWR sky130_fd_sc_hd__decap_8
XFILLER_0_25_101 VGND VGND VPWR VPWR sky130_fd_sc_hd__fill_2
X_1592_ _0795_ _0796_ VGND VGND VPWR VPWR _0797_ sky130_fd_sc_hd__nand2_1
X_1730_ net106 net154 VGND VGND VPWR VPWR _0250_ sky130_fd_sc_hd__nor2_1
XFILLER_0_40_126 VGND VGND VPWR VPWR sky130_fd_sc_hd__fill_2
X_1661_ regs.rx_data\[0\] net125 VGND VGND VPWR VPWR _0852_ sky130_fd_sc_hd__nand2_1
XFILLER_0_21_362 VPWR VGND VPWR VGND sky130_ef_sc_hd__decap_12
XTAP_579 VGND VPWR sky130_fd_sc_hd__tapvpwrvgnd_1
XTAP_568 VGND VPWR sky130_fd_sc_hd__tapvpwrvgnd_1
XTAP_557 VGND VPWR sky130_fd_sc_hd__tapvpwrvgnd_1
XTAP_546 VGND VPWR sky130_fd_sc_hd__tapvpwrvgnd_1
XTAP_535 VGND VPWR sky130_fd_sc_hd__tapvpwrvgnd_1
XTAP_524 VGND VPWR sky130_fd_sc_hd__tapvpwrvgnd_1
XTAP_513 VGND VPWR sky130_fd_sc_hd__tapvpwrvgnd_1
XTAP_502 VGND VPWR sky130_fd_sc_hd__tapvpwrvgnd_1
X_2144_ tx_fifo.fifo\[7\]\[3\] _0996_ net191 tx_fifo.fifo\[8\]\[3\] net196 tx_fifo.fifo\[0\]\[3\]
+ VGND VGND VPWR VPWR _1040_ sky130_fd_sc_hd__a222oi_1
X_2213_ _1091_ _1098_ VGND VGND VPWR VPWR _1099_ sky130_fd_sc_hd__nand2_1
XFILLER_0_72_75 VGND VGND VPWR VPWR sky130_fd_sc_hd__fill_1
XFILLER_0_72_53 VGND VGND VPWR VPWR sky130_fd_sc_hd__fill_2
XFILLER_0_48_248 VGND VGND VPWR VPWR sky130_fd_sc_hd__fill_1
XFILLER_0_8_301 VGND VGND VPWR VPWR sky130_fd_sc_hd__decap_6
X_2075_ _0952_ _0972_ VGND VGND VPWR VPWR _0983_ sky130_fd_sc_hd__nand2_1
X_2977_ clknet_leaf_8_clk _0164_ net243 VGND VGND VPWR VPWR rx.baud_cnt\[12\] sky130_fd_sc_hd__dfrtp_1
X_1859_ net68 _0889_ VGND VGND VPWR VPWR _0385_ sky130_fd_sc_hd__nor2_1
XFILLER_0_29_462 VGND VGND VPWR VPWR sky130_fd_sc_hd__fill_1
X_1928_ net66 _0901_ VGND VGND VPWR VPWR _0448_ sky130_fd_sc_hd__nor2_1
XFILLER_0_16_145 VGND VGND VPWR VPWR sky130_fd_sc_hd__decap_8
XFILLER_0_16_156 VPWR VGND VPWR VGND sky130_ef_sc_hd__decap_12
XFILLER_0_39_259 VGND VGND VPWR VPWR sky130_fd_sc_hd__decap_8
Xhold80 rx.baud_cnt\[13\] VGND VGND VPWR VPWR net341 sky130_fd_sc_hd__dlygate4sd3_1
X_2900_ clknet_leaf_30_clk net317 net259 VGND VGND VPWR VPWR rx_fifo.count\[4\] sky130_fd_sc_hd__dfrtp_2
Xhold91 rx.sample_cnt\[1\] VGND VGND VPWR VPWR net352 sky130_fd_sc_hd__dlygate4sd3_1
XFILLER_0_26_421 VGND VGND VPWR VPWR sky130_fd_sc_hd__fill_1
X_1713_ net118 net155 VGND VGND VPWR VPWR _0245_ sky130_fd_sc_hd__nor2_1
X_2831_ clknet_leaf_41_clk _0417_ net56 VGND VGND VPWR VPWR tx_fifo.fifo\[10\]\[4\]
+ sky130_fd_sc_hd__edfxtp_1
XFILLER_0_5_337 VGND VGND VPWR VPWR sky130_fd_sc_hd__decap_8
X_2762_ clknet_leaf_40_clk _0476_ net45 VGND VGND VPWR VPWR tx_fifo.fifo\[3\]\[7\]
+ sky130_fd_sc_hd__edfxtp_1
X_1644_ net210 net119 VGND VGND VPWR VPWR _0191_ sky130_fd_sc_hd__nor2_1
X_1575_ net22 _0730_ _0780_ _0728_ VGND VGND VPWR VPWR _0781_ sky130_fd_sc_hd__a22o_1
X_2693_ clknet_leaf_28_clk _0238_ net92 VGND VGND VPWR VPWR rx_fifo.fifo\[10\]\[1\]
+ sky130_fd_sc_hd__edfxtp_1
Xwire9 _0993_ VGND VGND VPWR VPWR net388 sky130_fd_sc_hd__dlymetal6s2s_1
XTAP_332 VGND VPWR sky130_fd_sc_hd__tapvpwrvgnd_1
XTAP_310 VGND VPWR sky130_fd_sc_hd__tapvpwrvgnd_1
XTAP_321 VGND VPWR sky130_fd_sc_hd__tapvpwrvgnd_1
X_2127_ tx_fifo.fifo\[5\]\[5\] net198 net197 tx_fifo.fifo\[12\]\[5\] _1004_ tx_fifo.fifo\[14\]\[5\]
+ VGND VGND VPWR VPWR _1025_ sky130_fd_sc_hd__a222oi_1
XTAP_398 VGND VPWR sky130_fd_sc_hd__tapvpwrvgnd_1
XTAP_387 VGND VPWR sky130_fd_sc_hd__tapvpwrvgnd_1
XTAP_376 VGND VPWR sky130_fd_sc_hd__tapvpwrvgnd_1
XTAP_365 VGND VPWR sky130_fd_sc_hd__tapvpwrvgnd_1
XTAP_354 VGND VPWR sky130_fd_sc_hd__tapvpwrvgnd_1
XTAP_343 VGND VPWR sky130_fd_sc_hd__tapvpwrvgnd_1
XFILLER_0_13_3 VPWR VGND VPWR VGND sky130_ef_sc_hd__decap_12
XFILLER_0_76_321 VGND VGND VPWR VPWR sky130_fd_sc_hd__decap_3
XFILLER_0_29_281 VPWR VGND VPWR VGND sky130_ef_sc_hd__decap_12
XPHY_49 VGND VGND VPWR VPWR sky130_fd_sc_hd__decap_3
XPHY_16 VGND VGND VPWR VPWR sky130_fd_sc_hd__decap_3
XPHY_27 VGND VGND VPWR VPWR sky130_fd_sc_hd__decap_3
X_2058_ rx.shift_reg\[1\] net340 _0967_ VGND VGND VPWR VPWR _0050_ sky130_fd_sc_hd__mux2_1
XPHY_38 VGND VGND VPWR VPWR sky130_fd_sc_hd__decap_3
XFILLER_0_44_284 VGND VGND VPWR VPWR sky130_fd_sc_hd__decap_6
XFILLER_0_8_197 VGND VGND VPWR VPWR sky130_fd_sc_hd__decap_6
XFILLER_0_12_170 VGND VGND VPWR VPWR sky130_fd_sc_hd__fill_2
XFILLER_0_67_321 VGND VGND VPWR VPWR sky130_fd_sc_hd__fill_2
XFILLER_0_67_365 VPWR VGND VPWR VGND sky130_ef_sc_hd__decap_12
X_1360_ divisor\[4\] _0567_ divisor\[5\] VGND VGND VPWR VPWR _0599_ sky130_fd_sc_hd__o21a_1
XFILLER_0_50_243 VGND VGND VPWR VPWR sky130_fd_sc_hd__decap_8
XFILLER_0_23_435 VGND VGND VPWR VPWR sky130_fd_sc_hd__fill_1
X_1291_ rx_fifo.head\[3\] net234 _0528_ VGND VGND VPWR VPWR _0533_ sky130_fd_sc_hd__nor3_1
XFILLER_0_37_12 VGND VGND VPWR VPWR sky130_fd_sc_hd__decap_8
Xclkbuf_leaf_43_clk clknet_2_0__leaf_clk VGND VGND VPWR VPWR clknet_leaf_43_clk sky130_fd_sc_hd__clkbuf_16
X_2676_ clknet_leaf_28_clk _0265_ _0018_ VGND VGND VPWR VPWR rx_fifo.fifo\[8\]\[6\]
+ sky130_fd_sc_hd__edfxtp_1
X_2814_ clknet_leaf_4_clk _0432_ net38 VGND VGND VPWR VPWR tx_fifo.fifo\[8\]\[3\]
+ sky130_fd_sc_hd__edfxtp_1
XFILLER_0_5_167 VGND VGND VPWR VPWR sky130_fd_sc_hd__fill_1
XFILLER_0_5_101 VGND VGND VPWR VPWR sky130_fd_sc_hd__decap_8
X_2745_ clknet_leaf_43_clk _0483_ net47 VGND VGND VPWR VPWR tx_fifo.fifo\[2\]\[6\]
+ sky130_fd_sc_hd__edfxtp_1
X_1489_ net364 _0654_ VGND VGND VPWR VPWR _0706_ sky130_fd_sc_hd__nor2_1
X_1627_ rx_fifo.fifo\[2\]\[0\] _0533_ net162 rx_fifo.fifo\[8\]\[0\] rx_fifo.fifo\[13\]\[0\]
+ net175 VGND VGND VPWR VPWR _0829_ sky130_fd_sc_hd__a222oi_1
X_1558_ net235 regs.dlh\[4\] net239 _0730_ loopback_en VGND VGND VPWR VPWR _0765_
+ sky130_fd_sc_hd__a32o_1
XTAP_184 VGND VPWR sky130_fd_sc_hd__tapvpwrvgnd_1
XTAP_173 VGND VPWR sky130_fd_sc_hd__tapvpwrvgnd_1
XTAP_162 VGND VPWR sky130_fd_sc_hd__tapvpwrvgnd_1
XFILLER_0_49_343 VGND VGND VPWR VPWR sky130_fd_sc_hd__decap_8
XTAP_195 VGND VPWR sky130_fd_sc_hd__tapvpwrvgnd_1
XFILLER_0_76_195 VGND VGND VPWR VPWR sky130_fd_sc_hd__fill_1
XFILLER_0_64_368 VGND VGND VPWR VPWR sky130_fd_sc_hd__decap_3
Xclkbuf_leaf_34_clk clknet_2_1__leaf_clk VGND VGND VPWR VPWR clknet_leaf_34_clk sky130_fd_sc_hd__clkbuf_16
XFILLER_0_32_265 VGND VGND VPWR VPWR sky130_fd_sc_hd__fill_2
XFILLER_0_32_232 VPWR VGND VPWR VGND sky130_ef_sc_hd__decap_12
XFILLER_0_2_3 VGND VGND VPWR VPWR sky130_fd_sc_hd__decap_8
XFILLER_0_67_184 VGND VGND VPWR VPWR sky130_fd_sc_hd__decap_8
Xclkbuf_leaf_25_clk clknet_2_3__leaf_clk VGND VGND VPWR VPWR clknet_leaf_25_clk sky130_fd_sc_hd__clkbuf_16
XFILLER_0_63_390 VGND VGND VPWR VPWR sky130_fd_sc_hd__fill_2
X_2530_ clknet_leaf_27_clk _0196_ net86 VGND VGND VPWR VPWR rx_fifo.fifo\[14\]\[3\]
+ sky130_fd_sc_hd__edfxtp_1
XFILLER_0_11_405 VGND VGND VPWR VPWR sky130_fd_sc_hd__fill_1
X_1412_ _0644_ net52 _0634_ VGND VGND VPWR VPWR _0371_ sky130_fd_sc_hd__nor3b_1
X_1343_ divisor\[13\] net134 VGND VGND VPWR VPWR _0582_ sky130_fd_sc_hd__xnor2_1
XFILLER_0_47_9 VPWR VGND VPWR VGND sky130_ef_sc_hd__decap_12
X_2392_ net307 net75 VGND VGND VPWR VPWR _1190_ sky130_fd_sc_hd__nand2_1
X_2461_ _0897_ net54 VGND VGND VPWR VPWR _0428_ sky130_fd_sc_hd__nor2_1
XFILLER_0_64_54 VGND VGND VPWR VPWR sky130_fd_sc_hd__decap_3
Xwire36 _1206_ VGND VGND VPWR VPWR net36 sky130_fd_sc_hd__clkbuf_1
X_1274_ _0516_ VGND VGND VPWR VPWR net17 sky130_fd_sc_hd__inv_2
XFILLER_0_73_132 VPWR VGND VPWR VGND sky130_ef_sc_hd__decap_12
Xclkbuf_leaf_16_clk clknet_2_3__leaf_clk VGND VGND VPWR VPWR clknet_leaf_16_clk sky130_fd_sc_hd__clkbuf_16
XFILLER_0_6_421 VPWR VGND VPWR VGND sky130_ef_sc_hd__decap_12
XFILLER_0_61_349 VPWR VGND VPWR VGND sky130_ef_sc_hd__decap_12
X_2659_ clknet_leaf_15_clk _0269_ net96 VGND VGND VPWR VPWR rx_fifo.fifo\[7\]\[0\]
+ sky130_fd_sc_hd__edfxtp_1
X_2728_ clknet_leaf_39_clk _0498_ _0013_ VGND VGND VPWR VPWR tx_fifo.fifo\[0\]\[5\]
+ sky130_fd_sc_hd__edfxtp_1
XFILLER_0_14_232 VGND VGND VPWR VPWR sky130_fd_sc_hd__decap_6
Xfanout167 _0532_ VGND VGND VPWR VPWR net167 sky130_fd_sc_hd__clkbuf_4
Xfanout101 _0852_ VGND VGND VPWR VPWR net101 sky130_fd_sc_hd__buf_4
Xfanout156 _0860_ VGND VGND VPWR VPWR net156 sky130_fd_sc_hd__clkbuf_4
Xfanout145 _0873_ VGND VGND VPWR VPWR net145 sky130_fd_sc_hd__clkbuf_4
Xfanout112 _0847_ VGND VGND VPWR VPWR net112 sky130_fd_sc_hd__clkbuf_4
XFILLER_0_69_449 VPWR VGND VPWR VGND sky130_ef_sc_hd__decap_12
XFILLER_0_49_151 VGND VGND VPWR VPWR sky130_fd_sc_hd__decap_8
XFILLER_0_20_257 VGND VGND VPWR VPWR sky130_fd_sc_hd__decap_6
XFILLER_0_18_47 VPWR VGND VPWR VGND sky130_ef_sc_hd__decap_12
XFILLER_0_55_165 VGND VGND VPWR VPWR sky130_fd_sc_hd__decap_3
XFILLER_0_55_143 VGND VGND VPWR VPWR sky130_fd_sc_hd__decap_3
X_1961_ net66 _0906_ VGND VGND VPWR VPWR _0480_ sky130_fd_sc_hd__nor2_1
X_1892_ net72 _0896_ VGND VGND VPWR VPWR _0419_ sky130_fd_sc_hd__nor2_1
X_2513_ tx.baud_cnt\[14\] _0637_ net363 VGND VGND VPWR VPWR _1248_ sky130_fd_sc_hd__a21oi_1
XFILLER_0_51_393 VGND VGND VPWR VPWR sky130_fd_sc_hd__decap_8
XFILLER_0_11_202 VGND VGND VPWR VPWR sky130_fd_sc_hd__decap_8
XFILLER_0_75_75 VGND VGND VPWR VPWR sky130_fd_sc_hd__fill_1
X_1326_ divisor\[2\] divisor\[0\] divisor\[1\] VGND VGND VPWR VPWR _0565_ sky130_fd_sc_hd__or3_2
X_2444_ regs.oe regs.err_pending net23 _1205_ _0727_ VGND VGND VPWR VPWR _1206_ sky130_fd_sc_hd__o41ai_1
Xclkbuf_leaf_5_clk clknet_2_0__leaf_clk VGND VGND VPWR VPWR clknet_leaf_5_clk sky130_fd_sc_hd__clkbuf_16
XFILLER_0_11_279 VGND VGND VPWR VPWR sky130_fd_sc_hd__fill_1
X_2375_ _1171_ _1172_ net34 VGND VGND VPWR VPWR _1173_ sky130_fd_sc_hd__a21oi_1
X_1257_ tx.state\[1\] VGND VGND VPWR VPWR _0502_ sky130_fd_sc_hd__inv_1
XFILLER_0_27_390 VGND VGND VPWR VPWR sky130_fd_sc_hd__fill_2
XFILLER_0_6_273 VPWR VGND VPWR VGND sky130_ef_sc_hd__decap_12
XFILLER_0_19_335 VGND VGND VPWR VPWR sky130_fd_sc_hd__fill_1
XFILLER_0_19_368 VGND VGND VPWR VPWR sky130_fd_sc_hd__decap_8
XFILLER_0_33_393 VGND VGND VPWR VPWR sky130_fd_sc_hd__fill_1
XFILLER_0_33_382 VGND VGND VPWR VPWR sky130_fd_sc_hd__decap_4
XFILLER_0_0_405 VPWR VGND VPWR VGND sky130_ef_sc_hd__decap_12
XTAP_739 VGND VPWR sky130_fd_sc_hd__tapvpwrvgnd_1
XTAP_728 VGND VPWR sky130_fd_sc_hd__tapvpwrvgnd_1
XTAP_717 VGND VPWR sky130_fd_sc_hd__tapvpwrvgnd_1
XTAP_706 VGND VPWR sky130_fd_sc_hd__tapvpwrvgnd_1
XFILLER_0_29_46 VGND VGND VPWR VPWR sky130_fd_sc_hd__fill_1
XFILLER_0_0_449 VGND VGND VPWR VPWR sky130_fd_sc_hd__decap_8
X_2160_ tx_fifo.fifo\[9\]\[2\] net192 _1005_ tx_fifo.fifo\[11\]\[2\] net185 tx_fifo.fifo\[2\]\[2\]
+ VGND VGND VPWR VPWR _1055_ sky130_fd_sc_hd__a222oi_1
XFILLER_0_45_78 VGND VGND VPWR VPWR sky130_fd_sc_hd__decap_3
XFILLER_0_0_25 VGND VGND VPWR VPWR sky130_fd_sc_hd__decap_3
X_2091_ tx.state\[2\] tx.state\[0\] _0502_ VGND VGND VPWR VPWR _0990_ sky130_fd_sc_hd__or3_2
XFILLER_0_75_249 VGND VGND VPWR VPWR sky130_fd_sc_hd__fill_1
X_2993_ clknet_leaf_11_clk _0360_ net245 VGND VGND VPWR VPWR tx.baud_cnt\[12\] sky130_fd_sc_hd__dfrtp_1
XFILLER_0_43_146 VGND VGND VPWR VPWR sky130_fd_sc_hd__fill_1
X_1875_ net73 _0893_ VGND VGND VPWR VPWR _0403_ sky130_fd_sc_hd__nor2_1
XFILLER_0_28_165 VGND VGND VPWR VPWR sky130_fd_sc_hd__decap_6
XFILLER_0_0_69 VPWR VGND VPWR VGND sky130_ef_sc_hd__decap_12
XFILLER_0_9_12 VGND VGND VPWR VPWR sky130_fd_sc_hd__decap_6
XFILLER_0_9_45 VGND VGND VPWR VPWR sky130_fd_sc_hd__decap_8
X_1944_ net66 _0903_ VGND VGND VPWR VPWR _0464_ sky130_fd_sc_hd__nor2_1
X_2427_ net234 _1086_ rx_fifo.head\[3\] VGND VGND VPWR VPWR _1200_ sky130_fd_sc_hd__a21oi_1
X_1309_ rx_fifo.fifo\[3\]\[9\] net176 net166 rx_fifo.fifo\[2\]\[9\] net161 rx_fifo.fifo\[9\]\[9\]
+ VGND VGND VPWR VPWR _0550_ sky130_fd_sc_hd__a222oi_1
XFILLER_0_43_3 VPWR VGND VPWR VGND sky130_ef_sc_hd__decap_12
X_2289_ net269 net8 _0160_ VGND VGND VPWR VPWR _0113_ sky130_fd_sc_hd__mux2_1
X_2358_ net219 _0905_ net58 VGND VGND VPWR VPWR _0009_ sky130_fd_sc_hd__nor3_2
XFILLER_0_34_179 VGND VGND VPWR VPWR sky130_fd_sc_hd__fill_1
XFILLER_0_15_371 VGND VGND VPWR VPWR sky130_fd_sc_hd__fill_1
XFILLER_0_15_393 VGND VGND VPWR VPWR sky130_fd_sc_hd__decap_8
XFILLER_0_38_430 VGND VGND VPWR VPWR sky130_fd_sc_hd__decap_6
Xwire140 net141 VGND VGND VPWR VPWR net140 sky130_fd_sc_hd__buf_1
X_1591_ regs.ier\[0\] net17 VGND VGND VPWR VPWR _0796_ sky130_fd_sc_hd__nand2_1
XTAP_525 VGND VPWR sky130_fd_sc_hd__tapvpwrvgnd_1
XTAP_514 VGND VPWR sky130_fd_sc_hd__tapvpwrvgnd_1
XTAP_503 VGND VPWR sky130_fd_sc_hd__tapvpwrvgnd_1
X_1660_ net210 net104 VGND VGND VPWR VPWR _0183_ sky130_fd_sc_hd__nor2_1
XFILLER_0_21_396 VGND VGND VPWR VPWR sky130_fd_sc_hd__decap_8
XFILLER_0_21_374 VGND VGND VPWR VPWR sky130_fd_sc_hd__decap_4
XFILLER_0_56_44 VGND VGND VPWR VPWR sky130_fd_sc_hd__fill_1
XTAP_569 VGND VPWR sky130_fd_sc_hd__tapvpwrvgnd_1
XTAP_558 VGND VPWR sky130_fd_sc_hd__tapvpwrvgnd_1
XTAP_547 VGND VPWR sky130_fd_sc_hd__tapvpwrvgnd_1
XTAP_536 VGND VPWR sky130_fd_sc_hd__tapvpwrvgnd_1
X_2212_ rx_fifo.count\[3\] _1097_ VGND VGND VPWR VPWR _1098_ sky130_fd_sc_hd__xnor2_1
X_2143_ net294 _0991_ _0992_ net296 _1039_ VGND VGND VPWR VPWR _0062_ sky130_fd_sc_hd__a221o_1
XFILLER_0_63_219 VGND VGND VPWR VPWR sky130_fd_sc_hd__decap_4
X_2074_ net232 _0944_ _0971_ VGND VGND VPWR VPWR _0982_ sky130_fd_sc_hd__nand3_1
X_2976_ clknet_leaf_8_clk _0163_ net243 VGND VGND VPWR VPWR rx.baud_cnt\[11\] sky130_fd_sc_hd__dfrtp_1
X_1858_ net70 _0889_ VGND VGND VPWR VPWR _0386_ sky130_fd_sc_hd__nor2_1
X_1927_ net68 _0901_ VGND VGND VPWR VPWR _0449_ sky130_fd_sc_hd__nor2_1
XFILLER_0_16_168 VGND VGND VPWR VPWR sky130_fd_sc_hd__decap_4
X_1789_ rx_fifo.tail\[2\] rx_fifo.tail\[3\] VGND VGND VPWR VPWR _0869_ sky130_fd_sc_hd__nor2_2
XFILLER_0_12_363 VGND VGND VPWR VPWR sky130_fd_sc_hd__fill_1
XFILLER_0_35_444 VGND VGND VPWR VPWR sky130_fd_sc_hd__decap_4
XFILLER_0_62_296 VPWR VGND VPWR VGND sky130_ef_sc_hd__decap_12
XFILLER_0_50_458 VGND VGND VPWR VPWR sky130_fd_sc_hd__decap_4
Xhold70 regs.dlh\[4\] VGND VGND VPWR VPWR net331 sky130_fd_sc_hd__dlygate4sd3_1
Xhold92 tx.bit_cnt\[0\] VGND VGND VPWR VPWR net353 sky130_fd_sc_hd__dlygate4sd3_1
Xhold81 tx.bit_cnt\[2\] VGND VGND VPWR VPWR net342 sky130_fd_sc_hd__dlygate4sd3_1
X_2830_ clknet_leaf_41_clk _0416_ net56 VGND VGND VPWR VPWR tx_fifo.fifo\[10\]\[3\]
+ sky130_fd_sc_hd__edfxtp_1
XFILLER_0_77_9 VPWR VGND VPWR VGND sky130_ef_sc_hd__decap_12
XANTENNA_1 _0531_ VGND VGND VPWR VPWR sky130_fd_sc_hd__diode_2
XFILLER_0_41_425 VGND VGND VPWR VPWR sky130_fd_sc_hd__decap_3
X_2692_ clknet_leaf_38_clk _0236_ net92 VGND VGND VPWR VPWR rx_fifo.fifo\[10\]\[0\]
+ sky130_fd_sc_hd__edfxtp_1
X_1712_ net120 net155 VGND VGND VPWR VPWR _0246_ sky130_fd_sc_hd__nor2_1
XFILLER_0_26_400 VGND VGND VPWR VPWR sky130_fd_sc_hd__fill_1
X_1643_ rx.framing_err net125 VGND VGND VPWR VPWR _0843_ sky130_fd_sc_hd__nand2_1
X_2761_ clknet_leaf_42_clk _0475_ _0009_ VGND VGND VPWR VPWR tx_fifo.fifo\[3\]\[6\]
+ sky130_fd_sc_hd__edfxtp_1
X_1574_ net236 _0506_ _0779_ VGND VGND VPWR VPWR _0780_ sky130_fd_sc_hd__o21ai_0
XTAP_366 VGND VPWR sky130_fd_sc_hd__tapvpwrvgnd_1
XTAP_355 VGND VPWR sky130_fd_sc_hd__tapvpwrvgnd_1
XTAP_344 VGND VPWR sky130_fd_sc_hd__tapvpwrvgnd_1
XTAP_333 VGND VPWR sky130_fd_sc_hd__tapvpwrvgnd_1
XFILLER_0_6_24 VGND VGND VPWR VPWR sky130_fd_sc_hd__decap_4
XTAP_300 VGND VPWR sky130_fd_sc_hd__tapvpwrvgnd_1
XTAP_311 VGND VPWR sky130_fd_sc_hd__tapvpwrvgnd_1
XTAP_322 VGND VPWR sky130_fd_sc_hd__tapvpwrvgnd_1
XTAP_399 VGND VPWR sky130_fd_sc_hd__tapvpwrvgnd_1
XTAP_388 VGND VPWR sky130_fd_sc_hd__tapvpwrvgnd_1
XTAP_377 VGND VPWR sky130_fd_sc_hd__tapvpwrvgnd_1
X_2126_ tx_fifo.fifo\[1\]\[5\] net189 net184 tx_fifo.fifo\[2\]\[5\] _1023_ VGND VGND
+ VPWR VPWR _1024_ sky130_fd_sc_hd__a221oi_2
XPHY_17 VGND VGND VPWR VPWR sky130_fd_sc_hd__decap_3
XPHY_28 VGND VGND VPWR VPWR sky130_fd_sc_hd__decap_3
X_2057_ net350 rx.shift_reg\[1\] _0967_ VGND VGND VPWR VPWR _0049_ sky130_fd_sc_hd__mux2_1
X_2959_ clknet_leaf_5_clk _0158_ net248 VGND VGND VPWR VPWR regs.rx_fifo_pop sky130_fd_sc_hd__dfrtp_4
XFILLER_0_29_293 VPWR VGND VPWR VGND sky130_ef_sc_hd__decap_12
XPHY_39 VGND VGND VPWR VPWR sky130_fd_sc_hd__decap_3
XFILLER_0_67_377 VGND VGND VPWR VPWR sky130_fd_sc_hd__decap_4
XFILLER_0_23_447 VGND VGND VPWR VPWR sky130_fd_sc_hd__fill_1
XFILLER_0_12_27 VGND VGND VPWR VPWR sky130_fd_sc_hd__fill_1
XFILLER_0_50_288 VPWR VGND VPWR VGND sky130_ef_sc_hd__decap_12
XFILLER_0_50_277 VGND VGND VPWR VPWR sky130_fd_sc_hd__decap_6
XFILLER_0_10_119 VPWR VGND VPWR VGND sky130_ef_sc_hd__decap_12
X_1290_ _0526_ _0528_ VGND VGND VPWR VPWR _0532_ sky130_fd_sc_hd__nor2_1
XFILLER_0_73_325 VGND VGND VPWR VPWR sky130_fd_sc_hd__fill_1
XFILLER_0_26_230 VGND VGND VPWR VPWR sky130_fd_sc_hd__decap_4
X_2813_ clknet_leaf_39_clk _0431_ _0002_ VGND VGND VPWR VPWR tx_fifo.fifo\[8\]\[2\]
+ sky130_fd_sc_hd__edfxtp_1
X_1626_ _0826_ _0827_ VGND VGND VPWR VPWR _0828_ sky130_fd_sc_hd__nand2_1
XFILLER_0_41_233 VGND VGND VPWR VPWR sky130_fd_sc_hd__fill_1
X_2675_ clknet_leaf_29_clk _0264_ net95 VGND VGND VPWR VPWR rx_fifo.fifo\[8\]\[5\]
+ sky130_fd_sc_hd__edfxtp_1
XFILLER_0_5_113 VPWR VGND VPWR VGND sky130_ef_sc_hd__decap_12
X_2744_ clknet_leaf_43_clk _0482_ net47 VGND VGND VPWR VPWR tx_fifo.fifo\[2\]\[5\]
+ sky130_fd_sc_hd__edfxtp_1
X_1488_ net74 _0705_ VGND VGND VPWR VPWR _0175_ sky130_fd_sc_hd__nor2_1
X_1557_ _0547_ _0763_ VGND VGND VPWR VPWR _0764_ sky130_fd_sc_hd__nor2_1
XTAP_196 VGND VPWR sky130_fd_sc_hd__tapvpwrvgnd_1
XTAP_185 VGND VPWR sky130_fd_sc_hd__tapvpwrvgnd_1
XFILLER_0_1_363 VPWR VGND VPWR VGND sky130_ef_sc_hd__decap_12
XTAP_174 VGND VPWR sky130_fd_sc_hd__tapvpwrvgnd_1
XTAP_163 VGND VPWR sky130_fd_sc_hd__tapvpwrvgnd_1
XFILLER_0_76_141 VPWR VGND VPWR VGND sky130_ef_sc_hd__decap_12
XFILLER_0_49_333 VGND VGND VPWR VPWR sky130_fd_sc_hd__decap_3
X_2109_ net231 net225 net226 net229 VGND VGND VPWR VPWR _1008_ sky130_fd_sc_hd__nor4bb_1
XFILLER_0_9_430 VPWR VGND VPWR VGND sky130_ef_sc_hd__decap_12
XFILLER_0_32_244 VGND VGND VPWR VPWR sky130_fd_sc_hd__decap_8
XFILLER_0_67_130 VGND VGND VPWR VPWR sky130_fd_sc_hd__decap_4
XFILLER_0_55_369 VGND VGND VPWR VPWR sky130_fd_sc_hd__decap_8
XFILLER_0_23_200 VGND VGND VPWR VPWR sky130_fd_sc_hd__fill_1
X_2460_ _0896_ net55 VGND VGND VPWR VPWR _0420_ sky130_fd_sc_hd__nor2_1
X_1411_ tx.baud_cnt\[8\] _0633_ VGND VGND VPWR VPWR _0644_ sky130_fd_sc_hd__nor2_1
X_1342_ divisor\[14\] net214 _0578_ divisor\[15\] VGND VGND VPWR VPWR _0581_ sky130_fd_sc_hd__o31ai_2
X_1273_ net216 rx_fifo.count\[4\] VGND VGND VPWR VPWR _0516_ sky130_fd_sc_hd__lpflow_isobufsrc_1
X_2391_ _1174_ _1188_ VGND VGND VPWR VPWR _1189_ sky130_fd_sc_hd__xnor2_1
XFILLER_0_73_144 VPWR VGND VPWR VGND sky130_ef_sc_hd__decap_12
XFILLER_0_46_303 VGND VGND VPWR VPWR sky130_fd_sc_hd__fill_2
XFILLER_0_6_433 VPWR VGND VPWR VGND sky130_ef_sc_hd__decap_12
XFILLER_0_13_92 VGND VGND VPWR VPWR sky130_fd_sc_hd__decap_4
XFILLER_0_73_3 VPWR VGND VPWR VGND sky130_ef_sc_hd__decap_12
Xfanout102 _0852_ VGND VGND VPWR VPWR net102 sky130_fd_sc_hd__buf_2
X_2589_ clknet_leaf_17_clk _0222_ net82 VGND VGND VPWR VPWR rx_fifo.fifo\[12\]\[7\]
+ sky130_fd_sc_hd__edfxtp_1
X_2658_ clknet_leaf_23_clk _0204_ net97 VGND VGND VPWR VPWR rx_fifo.fifo\[13\]\[10\]
+ sky130_fd_sc_hd__edfxtp_1
X_1609_ _0795_ _0812_ VGND VGND VPWR VPWR _0813_ sky130_fd_sc_hd__nand2_1
X_2727_ clknet_leaf_3_clk _0497_ net49 VGND VGND VPWR VPWR tx_fifo.fifo\[0\]\[4\]
+ sky130_fd_sc_hd__edfxtp_1
Xfanout113 net114 VGND VGND VPWR VPWR net113 sky130_fd_sc_hd__clkbuf_4
XFILLER_0_14_277 VGND VGND VPWR VPWR sky130_fd_sc_hd__fill_1
Xfanout168 _0531_ VGND VGND VPWR VPWR net168 sky130_fd_sc_hd__clkbuf_4
Xfanout157 _0858_ VGND VGND VPWR VPWR net157 sky130_fd_sc_hd__clkbuf_4
Xfanout146 _0872_ VGND VGND VPWR VPWR net146 sky130_fd_sc_hd__clkbuf_4
Xfanout124 _0839_ VGND VGND VPWR VPWR net124 sky130_fd_sc_hd__clkbuf_4
XFILLER_0_9_260 VGND VGND VPWR VPWR sky130_fd_sc_hd__fill_2
XFILLER_0_60_361 VGND VGND VPWR VPWR sky130_fd_sc_hd__decap_3
XFILLER_0_9_293 VGND VGND VPWR VPWR sky130_fd_sc_hd__fill_1
XFILLER_0_20_214 VGND VGND VPWR VPWR sky130_fd_sc_hd__decap_8
XFILLER_0_60_394 VGND VGND VPWR VPWR sky130_fd_sc_hd__decap_8
XFILLER_0_18_59 VGND VGND VPWR VPWR sky130_fd_sc_hd__fill_1
XFILLER_0_50_13 VGND VGND VPWR VPWR sky130_fd_sc_hd__decap_6
X_1960_ net68 _0906_ VGND VGND VPWR VPWR _0481_ sky130_fd_sc_hd__nor2_1
X_1891_ net208 net205 VGND VGND VPWR VPWR _0896_ sky130_fd_sc_hd__nand2_4
XFILLER_0_70_158 VGND VGND VPWR VPWR sky130_fd_sc_hd__decap_8
XFILLER_0_59_55 VGND VGND VPWR VPWR sky130_fd_sc_hd__fill_1
XFILLER_0_59_33 VGND VGND VPWR VPWR sky130_fd_sc_hd__fill_1
X_2443_ _0547_ _0556_ net178 VGND VGND VPWR VPWR _1205_ sky130_fd_sc_hd__a21oi_1
X_2512_ net218 _0880_ _1247_ VGND VGND VPWR VPWR _0152_ sky130_fd_sc_hd__nor3_1
XFILLER_0_3_447 VGND VGND VPWR VPWR sky130_fd_sc_hd__fill_1
XFILLER_0_11_225 VPWR VGND VPWR VGND sky130_ef_sc_hd__decap_12
XFILLER_0_75_87 VGND VGND VPWR VPWR sky130_fd_sc_hd__fill_2
X_1256_ divisor\[0\] VGND VGND VPWR VPWR _0501_ sky130_fd_sc_hd__inv_1
X_1325_ net178 _0564_ VGND VGND VPWR VPWR net23 sky130_fd_sc_hd__nor2_2
X_2374_ _1047_ _1059_ VGND VGND VPWR VPWR _1172_ sky130_fd_sc_hd__xor2_1
XFILLER_0_59_461 VGND VGND VPWR VPWR sky130_fd_sc_hd__fill_2
XFILLER_0_34_306 VGND VGND VPWR VPWR sky130_fd_sc_hd__fill_2
XFILLER_0_6_285 VGND VGND VPWR VPWR sky130_fd_sc_hd__decap_8
XFILLER_0_69_225 VPWR VGND VPWR VGND sky130_ef_sc_hd__decap_12
XFILLER_0_65_431 VPWR VGND VPWR VGND sky130_ef_sc_hd__decap_12
XFILLER_0_37_144 VGND VGND VPWR VPWR sky130_fd_sc_hd__decap_4
XFILLER_0_37_100 VGND VGND VPWR VPWR sky130_fd_sc_hd__fill_2
XTAP_707 VGND VPWR sky130_fd_sc_hd__tapvpwrvgnd_1
XFILLER_0_52_136 VGND VGND VPWR VPWR sky130_fd_sc_hd__decap_4
XFILLER_0_40_309 VPWR VGND VPWR VGND sky130_ef_sc_hd__decap_12
XFILLER_0_0_417 VGND VGND VPWR VPWR sky130_fd_sc_hd__decap_3
XFILLER_0_20_27 VGND VGND VPWR VPWR sky130_fd_sc_hd__fill_1
XTAP_729 VGND VPWR sky130_fd_sc_hd__tapvpwrvgnd_1
XTAP_718 VGND VPWR sky130_fd_sc_hd__tapvpwrvgnd_1
X_2090_ tx.state\[2\] tx.state\[0\] _0502_ VGND VGND VPWR VPWR _0989_ sky130_fd_sc_hd__nor3_1
X_2992_ clknet_leaf_11_clk _0359_ net245 VGND VGND VPWR VPWR tx.baud_cnt\[11\] sky130_fd_sc_hd__dfrtp_2
XFILLER_0_75_217 VGND VGND VPWR VPWR sky130_fd_sc_hd__decap_4
XFILLER_0_0_37 VGND VGND VPWR VPWR sky130_fd_sc_hd__fill_1
XFILLER_0_61_89 VPWR VGND VPWR VGND sky130_ef_sc_hd__decap_12
XFILLER_0_43_169 VPWR VGND VPWR VGND sky130_ef_sc_hd__decap_12
XFILLER_0_9_57 VGND VGND VPWR VPWR sky130_fd_sc_hd__decap_3
X_1943_ net69 _0903_ VGND VGND VPWR VPWR _0465_ sky130_fd_sc_hd__nor2_1
X_1874_ tx_fifo.tail\[2\] tx_fifo.tail\[3\] _0892_ VGND VGND VPWR VPWR _0893_ sky130_fd_sc_hd__nand3_4
X_2426_ net316 _1197_ _1199_ VGND VGND VPWR VPWR _0135_ sky130_fd_sc_hd__a21oi_1
XFILLER_0_10_93 VGND VGND VPWR VPWR sky130_fd_sc_hd__fill_2
X_1308_ rx_fifo.fifo\[7\]\[9\] net172 net162 rx_fifo.fifo\[8\]\[9\] VGND VGND VPWR
+ VPWR _0549_ sky130_fd_sc_hd__a22oi_1
X_2288_ net268 net9 net123 VGND VGND VPWR VPWR _0112_ sky130_fd_sc_hd__mux2_1
X_2357_ net218 _0893_ net59 VGND VGND VPWR VPWR _0010_ sky130_fd_sc_hd__nor3_2
XFILLER_0_62_401 VPWR VGND VPWR VGND sky130_ef_sc_hd__decap_12
XFILLER_0_19_111 VGND VGND VPWR VPWR sky130_fd_sc_hd__fill_1
XFILLER_0_62_456 VGND VGND VPWR VPWR sky130_fd_sc_hd__decap_6
XFILLER_0_57_239 VPWR VGND VPWR VGND sky130_ef_sc_hd__decap_12
Xwire130 _0790_ VGND VGND VPWR VPWR net130 sky130_fd_sc_hd__buf_1
XFILLER_0_53_423 VPWR VGND VPWR VGND sky130_ef_sc_hd__decap_12
Xwire174 _0524_ VGND VGND VPWR VPWR net174 sky130_fd_sc_hd__buf_1
Xwire141 _1045_ VGND VGND VPWR VPWR net141 sky130_fd_sc_hd__buf_1
X_1590_ regs.oe regs.err_pending regs.ier\[2\] VGND VGND VPWR VPWR _0795_ sky130_fd_sc_hd__o21ai_1
XTAP_548 VGND VPWR sky130_fd_sc_hd__tapvpwrvgnd_1
XTAP_537 VGND VPWR sky130_fd_sc_hd__tapvpwrvgnd_1
XTAP_526 VGND VPWR sky130_fd_sc_hd__tapvpwrvgnd_1
XTAP_515 VGND VPWR sky130_fd_sc_hd__tapvpwrvgnd_1
XTAP_504 VGND VPWR sky130_fd_sc_hd__tapvpwrvgnd_1
XFILLER_0_0_225 VPWR VGND VPWR VGND sky130_ef_sc_hd__decap_12
XTAP_559 VGND VPWR sky130_fd_sc_hd__tapvpwrvgnd_1
X_2211_ rx_fifo.count\[0\] rx_fifo.count\[2\] rx_fifo.count\[1\] VGND VGND VPWR VPWR
+ _1097_ sky130_fd_sc_hd__nand3_1
X_2142_ net75 _1038_ VGND VGND VPWR VPWR _1039_ sky130_fd_sc_hd__nor2_1
X_2073_ _0970_ _0976_ _0977_ rx.state\[0\] VGND VGND VPWR VPWR _0981_ sky130_fd_sc_hd__o31ai_1
X_2975_ clknet_leaf_8_clk _0162_ net243 VGND VGND VPWR VPWR rx.baud_cnt\[10\] sky130_fd_sc_hd__dfrtp_4
XFILLER_0_48_206 VGND VGND VPWR VPWR sky130_fd_sc_hd__fill_2
X_1788_ net102 _0868_ VGND VGND VPWR VPWR _0302_ sky130_fd_sc_hd__nor2_1
X_1857_ net73 _0889_ VGND VGND VPWR VPWR _0387_ sky130_fd_sc_hd__nor2_1
X_1926_ net71 _0901_ VGND VGND VPWR VPWR _0450_ sky130_fd_sc_hd__nor2_1
X_2409_ _0862_ net91 VGND VGND VPWR VPWR _0248_ sky130_fd_sc_hd__nor2_1
XFILLER_0_39_217 VGND VGND VPWR VPWR sky130_fd_sc_hd__decap_6
XFILLER_0_47_261 VPWR VGND VPWR VGND sky130_ef_sc_hd__decap_12
XFILLER_0_7_391 VGND VGND VPWR VPWR sky130_fd_sc_hd__fill_1
XFILLER_0_30_183 VPWR VGND VPWR VGND sky130_ef_sc_hd__decap_12
XFILLER_0_22_139 VGND VGND VPWR VPWR sky130_fd_sc_hd__fill_1
Xhold93 divisor\[7\] VGND VGND VPWR VPWR net354 sky130_fd_sc_hd__dlygate4sd3_1
Xhold71 regs.err_pending VGND VGND VPWR VPWR net332 sky130_fd_sc_hd__dlygate4sd3_1
XFILLER_0_26_26 VGND VGND VPWR VPWR sky130_fd_sc_hd__fill_2
XFILLER_0_26_15 VGND VGND VPWR VPWR sky130_fd_sc_hd__decap_4
Xhold82 tx.bit_cnt\[1\] VGND VGND VPWR VPWR net343 sky130_fd_sc_hd__dlygate4sd3_1
Xhold60 tx.parity_bit VGND VGND VPWR VPWR net321 sky130_fd_sc_hd__dlygate4sd3_1
XFILLER_0_42_47 VGND VGND VPWR VPWR sky130_fd_sc_hd__fill_1
XFILLER_0_38_283 VGND VGND VPWR VPWR sky130_fd_sc_hd__fill_1
XANTENNA_2 _0535_ VGND VGND VPWR VPWR sky130_fd_sc_hd__diode_2
XFILLER_0_53_220 VGND VGND VPWR VPWR sky130_fd_sc_hd__decap_4
X_2691_ clknet_leaf_25_clk _0248_ net94 VGND VGND VPWR VPWR rx_fifo.fifo\[9\]\[10\]
+ sky130_fd_sc_hd__edfxtp_1
X_1711_ _0853_ _0859_ VGND VGND VPWR VPWR _0861_ sky130_fd_sc_hd__nand2_1
X_1642_ net124 net210 VGND VGND VPWR VPWR _0842_ sky130_fd_sc_hd__nor2_1
X_2760_ clknet_leaf_41_clk _0474_ net45 VGND VGND VPWR VPWR tx_fifo.fifo\[3\]\[5\]
+ sky130_fd_sc_hd__edfxtp_1
XFILLER_0_67_88 VGND VGND VPWR VPWR sky130_fd_sc_hd__decap_6
XFILLER_0_67_44 VPWR VGND VPWR VGND sky130_ef_sc_hd__decap_12
X_1573_ net236 net274 VGND VGND VPWR VPWR _0779_ sky130_fd_sc_hd__nand2_1
XTAP_389 VGND VPWR sky130_fd_sc_hd__tapvpwrvgnd_1
XTAP_378 VGND VPWR sky130_fd_sc_hd__tapvpwrvgnd_1
XTAP_367 VGND VPWR sky130_fd_sc_hd__tapvpwrvgnd_1
XTAP_356 VGND VPWR sky130_fd_sc_hd__tapvpwrvgnd_1
XTAP_345 VGND VPWR sky130_fd_sc_hd__tapvpwrvgnd_1
XTAP_334 VGND VPWR sky130_fd_sc_hd__tapvpwrvgnd_1
XTAP_301 VGND VPWR sky130_fd_sc_hd__tapvpwrvgnd_1
XTAP_312 VGND VPWR sky130_fd_sc_hd__tapvpwrvgnd_1
XTAP_323 VGND VPWR sky130_fd_sc_hd__tapvpwrvgnd_1
XFILLER_0_76_301 VGND VGND VPWR VPWR sky130_fd_sc_hd__decap_6
X_2125_ tx_fifo.fifo\[13\]\[5\] _0999_ net188 tx_fifo.fifo\[4\]\[5\] VGND VGND VPWR
+ VPWR _1023_ sky130_fd_sc_hd__a22o_1
XPHY_18 VGND VGND VPWR VPWR sky130_fd_sc_hd__decap_3
XPHY_29 VGND VGND VPWR VPWR sky130_fd_sc_hd__decap_3
X_2056_ net377 net350 _0967_ VGND VGND VPWR VPWR _0048_ sky130_fd_sc_hd__mux2_1
XFILLER_0_44_253 VGND VGND VPWR VPWR sky130_fd_sc_hd__decap_8
X_2958_ clknet_leaf_5_clk _0159_ net248 VGND VGND VPWR VPWR regs.tx_fifo_clear sky130_fd_sc_hd__dfrtp_1
XFILLER_0_29_272 VGND VGND VPWR VPWR sky130_fd_sc_hd__decap_8
X_1909_ net71 _0898_ VGND VGND VPWR VPWR _0434_ sky130_fd_sc_hd__nor2_1
X_2889_ clknet_leaf_7_clk _0080_ net241 VGND VGND VPWR VPWR divisor\[13\] sky130_fd_sc_hd__dfrtp_2
XFILLER_0_67_334 VGND VGND VPWR VPWR sky130_fd_sc_hd__fill_2
XFILLER_0_35_253 VGND VGND VPWR VPWR sky130_fd_sc_hd__decap_3
XFILLER_0_2_309 VPWR VGND VPWR VGND sky130_ef_sc_hd__decap_12
XFILLER_0_53_57 VGND VGND VPWR VPWR sky130_fd_sc_hd__fill_1
XFILLER_0_73_337 VGND VGND VPWR VPWR sky130_fd_sc_hd__decap_8
X_2812_ clknet_leaf_38_clk _0430_ net38 VGND VGND VPWR VPWR tx_fifo.fifo\[8\]\[1\]
+ sky130_fd_sc_hd__edfxtp_1
XFILLER_0_26_253 VPWR VGND VPWR VGND sky130_ef_sc_hd__decap_12
XFILLER_0_5_125 VPWR VGND VPWR VGND sky130_ef_sc_hd__decap_12
X_2743_ clknet_leaf_43_clk _0481_ net47 VGND VGND VPWR VPWR tx_fifo.fifo\[2\]\[4\]
+ sky130_fd_sc_hd__edfxtp_1
X_1625_ rx_fifo.fifo\[14\]\[0\] _0529_ net169 rx_fifo.fifo\[6\]\[0\] VGND VGND VPWR
+ VPWR _0827_ sky130_fd_sc_hd__a22oi_1
X_1556_ net17 _0727_ VGND VGND VPWR VPWR _0763_ sky130_fd_sc_hd__nand2_1
XFILLER_0_41_223 VGND VGND VPWR VPWR sky130_fd_sc_hd__fill_1
X_2674_ clknet_leaf_29_clk _0263_ net95 VGND VGND VPWR VPWR rx_fifo.fifo\[8\]\[4\]
+ sky130_fd_sc_hd__edfxtp_1
XFILLER_0_5_169 VGND VGND VPWR VPWR sky130_fd_sc_hd__decap_8
XFILLER_0_5_147 VPWR VGND VPWR VGND sky130_ef_sc_hd__decap_12
XFILLER_0_1_375 VPWR VGND VPWR VGND sky130_ef_sc_hd__decap_12
XFILLER_0_14_437 VGND VGND VPWR VPWR sky130_fd_sc_hd__fill_1
X_1487_ rx.baud_cnt\[8\] _0655_ VGND VGND VPWR VPWR _0705_ sky130_fd_sc_hd__xnor2_1
XTAP_197 VGND VPWR sky130_fd_sc_hd__tapvpwrvgnd_1
XTAP_186 VGND VPWR sky130_fd_sc_hd__tapvpwrvgnd_1
XTAP_175 VGND VPWR sky130_fd_sc_hd__tapvpwrvgnd_1
XTAP_164 VGND VPWR sky130_fd_sc_hd__tapvpwrvgnd_1
XFILLER_0_76_153 VPWR VGND VPWR VGND sky130_ef_sc_hd__decap_12
XFILLER_0_64_326 VGND VGND VPWR VPWR sky130_fd_sc_hd__fill_1
X_2108_ tx_fifo.fifo\[4\]\[6\] _1006_ VGND VGND VPWR VPWR _1007_ sky130_fd_sc_hd__nand2_1
XFILLER_0_9_442 VGND VGND VPWR VPWR sky130_fd_sc_hd__decap_6
X_2039_ _0945_ _0950_ _0955_ VGND VGND VPWR VPWR _0957_ sky130_fd_sc_hd__or3_1
XFILLER_0_76_197 VPWR VGND VPWR VGND sky130_ef_sc_hd__decap_12
XFILLER_0_17_253 VGND VGND VPWR VPWR sky130_fd_sc_hd__decap_4
XFILLER_0_67_142 VGND VGND VPWR VPWR sky130_fd_sc_hd__decap_4
X_1410_ net52 _0643_ VGND VGND VPWR VPWR _0372_ sky130_fd_sc_hd__nor2_1
XFILLER_0_70_329 VPWR VGND VPWR VGND sky130_ef_sc_hd__decap_12
XFILLER_0_23_223 VGND VGND VPWR VPWR sky130_fd_sc_hd__fill_1
XFILLER_0_2_139 VGND VGND VPWR VPWR sky130_fd_sc_hd__fill_1
XFILLER_0_64_23 VGND VGND VPWR VPWR sky130_fd_sc_hd__fill_1
X_1341_ divisor\[14\] _0579_ VGND VGND VPWR VPWR _0580_ sky130_fd_sc_hd__xor2_1
X_1272_ rx_fifo.count\[0\] rx_fifo.count\[2\] rx_fifo.count\[3\] rx_fifo.count\[1\]
+ VGND VGND VPWR VPWR _0515_ sky130_fd_sc_hd__nor4_1
X_2390_ _1170_ _1187_ VGND VGND VPWR VPWR _1188_ sky130_fd_sc_hd__xnor2_1
XFILLER_0_73_156 VPWR VGND VPWR VGND sky130_ef_sc_hd__decap_12
X_2726_ clknet_leaf_5_clk _0496_ net49 VGND VGND VPWR VPWR tx_fifo.fifo\[0\]\[3\]
+ sky130_fd_sc_hd__edfxtp_1
XFILLER_0_6_445 VPWR VGND VPWR VGND sky130_ef_sc_hd__decap_12
XFILLER_0_66_3 VPWR VGND VPWR VGND sky130_ef_sc_hd__decap_12
X_2657_ clknet_leaf_17_clk _0213_ net97 VGND VGND VPWR VPWR rx_fifo.fifo\[13\]\[9\]
+ sky130_fd_sc_hd__edfxtp_1
Xfanout103 net104 VGND VGND VPWR VPWR net103 sky130_fd_sc_hd__clkbuf_4
X_1608_ regs.ier\[1\] net34 _0796_ VGND VGND VPWR VPWR _0812_ sky130_fd_sc_hd__nand3_1
X_2588_ clknet_leaf_26_clk _0221_ net82 VGND VGND VPWR VPWR rx_fifo.fifo\[12\]\[6\]
+ sky130_fd_sc_hd__edfxtp_1
X_1539_ _0741_ _0742_ _0746_ VGND VGND VPWR VPWR _0747_ sky130_fd_sc_hd__nand3_1
Xfanout147 _0871_ VGND VGND VPWR VPWR net147 sky130_fd_sc_hd__clkbuf_4
Xfanout114 _0846_ VGND VGND VPWR VPWR net114 sky130_fd_sc_hd__buf_2
Xfanout125 net126 VGND VGND VPWR VPWR net125 sky130_fd_sc_hd__buf_2
XFILLER_0_69_429 VPWR VGND VPWR VGND sky130_ef_sc_hd__decap_12
Xfanout169 _0530_ VGND VGND VPWR VPWR net169 sky130_fd_sc_hd__buf_4
Xfanout158 _0856_ VGND VGND VPWR VPWR net158 sky130_fd_sc_hd__clkbuf_4
XFILLER_0_49_197 VGND VGND VPWR VPWR sky130_fd_sc_hd__fill_2
XFILLER_0_20_226 VGND VGND VPWR VPWR sky130_fd_sc_hd__fill_1
XFILLER_0_18_27 VGND VGND VPWR VPWR sky130_fd_sc_hd__fill_1
XFILLER_0_68_462 VGND VGND VPWR VPWR sky130_fd_sc_hd__fill_1
XFILLER_0_34_15 VGND VGND VPWR VPWR sky130_fd_sc_hd__decap_8
X_1890_ net60 _0895_ VGND VGND VPWR VPWR _0405_ sky130_fd_sc_hd__nor2_1
X_2511_ tx_fifo.tail\[2\] _0878_ tx_fifo.tail\[3\] VGND VGND VPWR VPWR _1247_ sky130_fd_sc_hd__a21oi_1
XFILLER_0_11_237 VPWR VGND VPWR VGND sky130_ef_sc_hd__decap_12
X_2442_ _0895_ net55 VGND VGND VPWR VPWR _0412_ sky130_fd_sc_hd__nor2_1
X_2373_ _1068_ _1079_ VGND VGND VPWR VPWR _1171_ sky130_fd_sc_hd__xor2_1
XFILLER_0_75_55 VGND VGND VPWR VPWR sky130_fd_sc_hd__fill_1
X_1324_ rx_fifo.fifo\[6\]\[8\] net169 net165 rx_fifo.fifo\[12\]\[8\] _0563_ VGND VGND
+ VPWR VPWR _0564_ sky130_fd_sc_hd__a221oi_4
XFILLER_0_74_421 VPWR VGND VPWR VGND sky130_ef_sc_hd__decap_12
XFILLER_0_19_337 VGND VGND VPWR VPWR sky130_fd_sc_hd__decap_4
XFILLER_0_40_91 VGND VGND VPWR VPWR sky130_fd_sc_hd__fill_2
X_2709_ clknet_leaf_3_clk _0383_ net51 VGND VGND VPWR VPWR tx_fifo.fifo\[14\]\[2\]
+ sky130_fd_sc_hd__edfxtp_1
XFILLER_0_6_253 VGND VGND VPWR VPWR sky130_fd_sc_hd__decap_4
XFILLER_0_6_297 VGND VGND VPWR VPWR sky130_fd_sc_hd__decap_8
XFILLER_0_10_270 VGND VGND VPWR VPWR sky130_fd_sc_hd__decap_4
XFILLER_0_10_281 VGND VGND VPWR VPWR sky130_fd_sc_hd__fill_1
XFILLER_0_69_237 VGND VGND VPWR VPWR sky130_fd_sc_hd__fill_2
XFILLER_0_4_80 VGND VGND VPWR VPWR sky130_fd_sc_hd__decap_4
XFILLER_0_77_281 VPWR VGND VPWR VGND sky130_ef_sc_hd__decap_12
XFILLER_0_65_443 VGND VGND VPWR VPWR sky130_fd_sc_hd__decap_4
XFILLER_0_52_115 VGND VGND VPWR VPWR sky130_fd_sc_hd__fill_1
XTAP_719 VGND VPWR sky130_fd_sc_hd__tapvpwrvgnd_1
XTAP_708 VGND VPWR sky130_fd_sc_hd__tapvpwrvgnd_1
XFILLER_0_0_429 VGND VGND VPWR VPWR sky130_fd_sc_hd__fill_1
X_2991_ clknet_leaf_11_clk _0358_ net245 VGND VGND VPWR VPWR tx.baud_cnt\[10\] sky130_fd_sc_hd__dfrtp_1
XFILLER_0_28_101 VGND VGND VPWR VPWR sky130_fd_sc_hd__decap_8
X_1942_ net70 _0903_ VGND VGND VPWR VPWR _0466_ sky130_fd_sc_hd__nor2_1
XFILLER_0_16_307 VGND VGND VPWR VPWR sky130_fd_sc_hd__fill_1
X_1873_ tx_fifo.tail\[1\] net223 VGND VGND VPWR VPWR _0892_ sky130_fd_sc_hd__nor2_4
XFILLER_0_3_278 VGND VGND VPWR VPWR sky130_fd_sc_hd__fill_2
X_2425_ rx_fifo.count\[4\] _1197_ _1198_ VGND VGND VPWR VPWR _1199_ sky130_fd_sc_hd__o21ai_0
XFILLER_0_10_83 VGND VGND VPWR VPWR sky130_fd_sc_hd__fill_1
X_2356_ net219 _0906_ net58 VGND VGND VPWR VPWR _0011_ sky130_fd_sc_hd__nor3_1
XFILLER_0_19_81 VGND VGND VPWR VPWR sky130_fd_sc_hd__fill_2
XFILLER_0_19_92 VGND VGND VPWR VPWR sky130_fd_sc_hd__fill_2
X_1307_ rx_fifo.fifo\[4\]\[9\] net173 net165 rx_fifo.fifo\[12\]\[9\] net164 rx_fifo.fifo\[15\]\[9\]
+ VGND VGND VPWR VPWR _0548_ sky130_fd_sc_hd__a222oi_1
X_2287_ net265 net10 net123 VGND VGND VPWR VPWR _0111_ sky130_fd_sc_hd__mux2_1
XFILLER_0_74_251 VGND VGND VPWR VPWR sky130_fd_sc_hd__fill_1
XFILLER_0_66_229 VGND VGND VPWR VPWR sky130_fd_sc_hd__fill_2
XFILLER_0_62_413 VGND VGND VPWR VPWR sky130_fd_sc_hd__decap_6
XFILLER_0_19_167 VGND VGND VPWR VPWR sky130_fd_sc_hd__fill_1
XFILLER_0_19_189 VGND VGND VPWR VPWR sky130_fd_sc_hd__fill_2
XFILLER_0_15_39 VGND VGND VPWR VPWR sky130_fd_sc_hd__decap_4
XFILLER_0_65_295 VPWR VGND VPWR VGND sky130_ef_sc_hd__decap_12
Xwire131 _0772_ VGND VGND VPWR VPWR net131 sky130_fd_sc_hd__buf_1
XFILLER_0_53_435 VPWR VGND VPWR VGND sky130_ef_sc_hd__decap_12
XFILLER_0_53_402 VGND VGND VPWR VPWR sky130_fd_sc_hd__fill_1
XFILLER_0_40_118 VGND VGND VPWR VPWR sky130_fd_sc_hd__decap_8
Xwire142 _1040_ VGND VGND VPWR VPWR net142 sky130_fd_sc_hd__clkbuf_1
XFILLER_0_25_159 VGND VGND VPWR VPWR sky130_fd_sc_hd__fill_1
Xwire186 _1008_ VGND VGND VPWR VPWR net186 sky130_fd_sc_hd__clkbuf_2
XTAP_549 VGND VPWR sky130_fd_sc_hd__tapvpwrvgnd_1
XTAP_538 VGND VPWR sky130_fd_sc_hd__tapvpwrvgnd_1
XTAP_527 VGND VPWR sky130_fd_sc_hd__tapvpwrvgnd_1
XTAP_516 VGND VPWR sky130_fd_sc_hd__tapvpwrvgnd_1
XTAP_505 VGND VPWR sky130_fd_sc_hd__tapvpwrvgnd_1
X_2210_ rx_fifo.count\[0\] rx_fifo.count\[1\] VGND VGND VPWR VPWR _1096_ sky130_fd_sc_hd__nand2_1
XFILLER_0_21_332 VGND VGND VPWR VPWR sky130_fd_sc_hd__decap_4
XFILLER_0_0_237 VPWR VGND VPWR VGND sky130_ef_sc_hd__decap_12
X_2141_ _1035_ _1037_ VGND VGND VPWR VPWR _1038_ sky130_fd_sc_hd__nor2_1
X_2072_ net77 _0980_ _0979_ _0978_ VGND VGND VPWR VPWR _0051_ sky130_fd_sc_hd__o211ai_1
X_2974_ clknet_leaf_8_clk _0176_ net243 VGND VGND VPWR VPWR rx.baud_cnt\[9\] sky130_fd_sc_hd__dfrtp_1
X_1925_ net72 _0901_ VGND VGND VPWR VPWR _0451_ sky130_fd_sc_hd__nor2_1
X_1787_ net104 _0868_ VGND VGND VPWR VPWR _0304_ sky130_fd_sc_hd__nor2_1
X_1856_ tx_fifo.tail\[2\] tx_fifo.tail\[3\] _0888_ VGND VGND VPWR VPWR _0889_ sky130_fd_sc_hd__nand3_4
X_2339_ net221 net157 _1164_ VGND VGND VPWR VPWR _0026_ sky130_fd_sc_hd__nor3_2
X_2408_ _0986_ _1192_ VGND VGND VPWR VPWR _0179_ sky130_fd_sc_hd__nor2_1
XFILLER_0_50_427 VGND VGND VPWR VPWR sky130_fd_sc_hd__decap_4
XFILLER_0_47_273 VGND VGND VPWR VPWR sky130_fd_sc_hd__decap_6
XFILLER_0_30_195 VGND VGND VPWR VPWR sky130_fd_sc_hd__fill_1
Xhold94 divisor\[1\] VGND VGND VPWR VPWR net355 sky130_fd_sc_hd__dlygate4sd3_1
Xhold50 _0059_ VGND VGND VPWR VPWR net311 sky130_fd_sc_hd__dlygate4sd3_1
Xhold72 rx.sample_cnt\[0\] VGND VGND VPWR VPWR net333 sky130_fd_sc_hd__dlygate4sd3_1
Xhold83 rx.shift_reg\[7\] VGND VGND VPWR VPWR net344 sky130_fd_sc_hd__dlygate4sd3_1
Xhold61 _0155_ VGND VGND VPWR VPWR net322 sky130_fd_sc_hd__dlygate4sd3_1
XFILLER_0_42_15 VPWR VGND VPWR VGND sky130_ef_sc_hd__decap_12
XFILLER_0_5_318 VPWR VGND VPWR VGND sky130_ef_sc_hd__decap_12
X_2690_ clknet_leaf_23_clk _0257_ net93 VGND VGND VPWR VPWR rx_fifo.fifo\[9\]\[9\]
+ sky130_fd_sc_hd__edfxtp_1
X_1572_ _0556_ _0763_ VGND VGND VPWR VPWR _0778_ sky130_fd_sc_hd__nor2_1
XANTENNA_3 _1217_ VGND VGND VPWR VPWR sky130_fd_sc_hd__diode_2
X_1710_ net101 net156 VGND VGND VPWR VPWR _0225_ sky130_fd_sc_hd__nor2_1
XFILLER_0_41_449 VGND VGND VPWR VPWR sky130_fd_sc_hd__decap_6
X_1641_ rx_fifo.tail\[2\] rx_fifo.tail\[1\] net233 rx_fifo.tail\[3\] VGND VGND VPWR
+ VPWR _0841_ sky130_fd_sc_hd__nand4_4
XFILLER_0_6_15 VGND VGND VPWR VPWR sky130_fd_sc_hd__decap_6
XFILLER_0_13_118 VGND VGND VPWR VPWR sky130_fd_sc_hd__fill_1
XTAP_379 VGND VPWR sky130_fd_sc_hd__tapvpwrvgnd_1
XTAP_368 VGND VPWR sky130_fd_sc_hd__tapvpwrvgnd_1
XTAP_357 VGND VPWR sky130_fd_sc_hd__tapvpwrvgnd_1
XTAP_346 VGND VPWR sky130_fd_sc_hd__tapvpwrvgnd_1
XTAP_335 VGND VPWR sky130_fd_sc_hd__tapvpwrvgnd_1
X_2124_ tx_fifo.fifo\[11\]\[5\] _1005_ _1009_ tx_fifo.fifo\[15\]\[5\] _1020_ VGND
+ VGND VPWR VPWR _1022_ sky130_fd_sc_hd__a221oi_1
XTAP_302 VGND VPWR sky130_fd_sc_hd__tapvpwrvgnd_1
XTAP_313 VGND VPWR sky130_fd_sc_hd__tapvpwrvgnd_1
XTAP_324 VGND VPWR sky130_fd_sc_hd__tapvpwrvgnd_1
XPHY_19 VGND VGND VPWR VPWR sky130_fd_sc_hd__decap_3
X_2055_ net347 rx.shift_reg\[3\] _0967_ VGND VGND VPWR VPWR _0047_ sky130_fd_sc_hd__mux2_1
X_2957_ clknet_leaf_13_clk regs.int_pending net250 VGND VGND VPWR VPWR net20 sky130_fd_sc_hd__dfrtp_1
X_2888_ clknet_leaf_9_clk _0081_ net242 VGND VGND VPWR VPWR divisor\[12\] sky130_fd_sc_hd__dfrtp_4
X_1908_ net73 _0898_ VGND VGND VPWR VPWR _0435_ sky130_fd_sc_hd__nor2_1
X_1839_ tx_fifo.tail\[1\] net223 tx_fifo.tail\[2\] tx_fifo.tail\[3\] VGND VGND VPWR
+ VPWR _0879_ sky130_fd_sc_hd__nand4_4
XFILLER_0_17_424 VGND VGND VPWR VPWR sky130_fd_sc_hd__fill_1
XFILLER_0_4_9 VGND VGND VPWR VPWR sky130_fd_sc_hd__fill_2
Xclkbuf_leaf_37_clk clknet_2_1__leaf_clk VGND VGND VPWR VPWR clknet_leaf_37_clk sky130_fd_sc_hd__clkbuf_16
XFILLER_0_35_221 VGND VGND VPWR VPWR sky130_fd_sc_hd__decap_3
Xclkbuf_leaf_28_clk clknet_2_1__leaf_clk VGND VGND VPWR VPWR clknet_leaf_28_clk sky130_fd_sc_hd__clkbuf_16
XFILLER_0_26_287 VPWR VGND VPWR VGND sky130_ef_sc_hd__decap_12
XFILLER_0_26_265 VPWR VGND VPWR VGND sky130_ef_sc_hd__decap_12
X_2811_ clknet_leaf_4_clk _0429_ _0002_ VGND VGND VPWR VPWR tx_fifo.fifo\[8\]\[0\]
+ sky130_fd_sc_hd__edfxtp_1
XFILLER_0_5_159 VGND VGND VPWR VPWR sky130_fd_sc_hd__decap_8
XFILLER_0_5_137 VGND VGND VPWR VPWR sky130_fd_sc_hd__decap_3
X_2742_ clknet_leaf_43_clk _0480_ net47 VGND VGND VPWR VPWR tx_fifo.fifo\[2\]\[3\]
+ sky130_fd_sc_hd__edfxtp_1
XFILLER_0_14_416 VGND VGND VPWR VPWR sky130_fd_sc_hd__decap_4
X_1624_ rx_fifo.fifo\[4\]\[0\] net173 _0534_ rx_fifo.fifo\[12\]\[0\] VGND VGND VPWR
+ VPWR _0826_ sky130_fd_sc_hd__a22oi_1
X_1555_ divisor\[4\] net236 _0716_ _0761_ VGND VGND VPWR VPWR _0762_ sky130_fd_sc_hd__a22oi_1
X_2673_ clknet_leaf_27_clk _0262_ net95 VGND VGND VPWR VPWR rx_fifo.fifo\[8\]\[3\]
+ sky130_fd_sc_hd__edfxtp_1
XFILLER_0_1_387 VGND VGND VPWR VPWR sky130_fd_sc_hd__decap_4
Xclkbuf_leaf_19_clk clknet_2_3__leaf_clk VGND VGND VPWR VPWR clknet_leaf_19_clk sky130_fd_sc_hd__clkbuf_16
X_1486_ _0656_ net74 _0704_ VGND VGND VPWR VPWR _0176_ sky130_fd_sc_hd__nor3_1
XTAP_198 VGND VPWR sky130_fd_sc_hd__tapvpwrvgnd_1
XTAP_187 VGND VPWR sky130_fd_sc_hd__tapvpwrvgnd_1
XTAP_176 VGND VPWR sky130_fd_sc_hd__tapvpwrvgnd_1
XTAP_165 VGND VPWR sky130_fd_sc_hd__tapvpwrvgnd_1
X_2107_ net228 net230 net224 net226 VGND VGND VPWR VPWR _1006_ sky130_fd_sc_hd__nor4b_4
XFILLER_0_76_165 VPWR VGND VPWR VGND sky130_ef_sc_hd__decap_12
X_2038_ _0945_ _0950_ _0955_ VGND VGND VPWR VPWR _0956_ sky130_fd_sc_hd__nor3_1
XFILLER_0_20_419 VGND VGND VPWR VPWR sky130_fd_sc_hd__fill_1
XFILLER_0_63_393 VGND VGND VPWR VPWR sky130_fd_sc_hd__fill_1
X_1340_ net214 _0578_ VGND VGND VPWR VPWR _0579_ sky130_fd_sc_hd__nor2_1
XFILLER_0_48_58 VPWR VGND VPWR VGND sky130_ef_sc_hd__decap_12
XFILLER_0_64_79 VGND VGND VPWR VPWR sky130_fd_sc_hd__fill_2
XFILLER_0_64_46 VGND VGND VPWR VPWR sky130_fd_sc_hd__decap_4
X_1271_ rx_fifo.count\[0\] rx_fifo.count\[1\] VGND VGND VPWR VPWR _0514_ sky130_fd_sc_hd__nor2_1
XFILLER_0_73_113 VPWR VGND VPWR VGND sky130_ef_sc_hd__decap_12
XFILLER_0_13_50 VGND VGND VPWR VPWR sky130_fd_sc_hd__decap_6
X_2656_ clknet_leaf_17_clk _0212_ net97 VGND VGND VPWR VPWR rx_fifo.fifo\[13\]\[8\]
+ sky130_fd_sc_hd__edfxtp_1
Xclkbuf_leaf_8_clk clknet_2_2__leaf_clk VGND VGND VPWR VPWR clknet_leaf_8_clk sky130_fd_sc_hd__clkbuf_16
X_2725_ clknet_leaf_3_clk _0495_ net49 VGND VGND VPWR VPWR tx_fifo.fifo\[0\]\[2\]
+ sky130_fd_sc_hd__edfxtp_1
XFILLER_0_6_457 VGND VGND VPWR VPWR sky130_fd_sc_hd__decap_6
X_2587_ clknet_leaf_19_clk _0220_ _0026_ VGND VGND VPWR VPWR rx_fifo.fifo\[12\]\[5\]
+ sky130_fd_sc_hd__edfxtp_1
X_1538_ rx_fifo.fifo\[7\]\[5\] net172 net171 rx_fifo.fifo\[11\]\[5\] _0745_ VGND VGND
+ VPWR VPWR _0746_ sky130_fd_sc_hd__a221oi_2
X_1607_ divisor\[1\] net236 _0716_ _0810_ VGND VGND VPWR VPWR _0811_ sky130_fd_sc_hd__a22oi_1
X_1469_ _0676_ _0677_ _0678_ _0680_ _0689_ VGND VGND VPWR VPWR _0690_ sky130_fd_sc_hd__o2111ai_2
XFILLER_0_59_3 VPWR VGND VPWR VGND sky130_ef_sc_hd__decap_12
Xfanout148 _0870_ VGND VGND VPWR VPWR net148 sky130_fd_sc_hd__clkbuf_4
Xfanout159 _0854_ VGND VGND VPWR VPWR net159 sky130_fd_sc_hd__clkbuf_4
Xfanout115 _0845_ VGND VGND VPWR VPWR net115 sky130_fd_sc_hd__clkbuf_4
Xfanout126 _0838_ VGND VGND VPWR VPWR net126 sky130_fd_sc_hd__clkbuf_4
Xfanout104 _0851_ VGND VGND VPWR VPWR net104 sky130_fd_sc_hd__clkbuf_4
XFILLER_0_1_151 VPWR VGND VPWR VGND sky130_ef_sc_hd__decap_12
XFILLER_0_77_441 VGND VGND VPWR VPWR sky130_fd_sc_hd__decap_6
XFILLER_0_45_393 VGND VGND VPWR VPWR sky130_fd_sc_hd__decap_8
XFILLER_0_20_249 VGND VGND VPWR VPWR sky130_fd_sc_hd__decap_3
XFILLER_0_34_49 VGND VGND VPWR VPWR sky130_fd_sc_hd__fill_1
XFILLER_0_70_149 VGND VGND VPWR VPWR sky130_fd_sc_hd__fill_2
XFILLER_0_55_157 VGND VGND VPWR VPWR sky130_fd_sc_hd__decap_8
XFILLER_0_50_37 VGND VGND VPWR VPWR sky130_fd_sc_hd__fill_1
XFILLER_0_36_393 VPWR VGND VPWR VGND sky130_ef_sc_hd__decap_12
X_2510_ _0912_ _1009_ _1246_ net220 VGND VGND VPWR VPWR _0151_ sky130_fd_sc_hd__a211oi_1
XFILLER_0_3_449 VPWR VGND VPWR VGND sky130_ef_sc_hd__decap_12
XFILLER_0_3_405 VPWR VGND VPWR VGND sky130_ef_sc_hd__decap_12
XFILLER_0_59_57 VPWR VGND VPWR VGND sky130_ef_sc_hd__decap_12
X_1323_ net381 _0559_ _0561_ _0562_ VGND VGND VPWR VPWR _0563_ sky130_fd_sc_hd__nand4_2
X_2372_ _1027_ _1038_ _1169_ VGND VGND VPWR VPWR _1170_ sky130_fd_sc_hd__a21oi_1
XFILLER_0_11_249 VPWR VGND VPWR VGND sky130_ef_sc_hd__decap_12
X_2441_ _0502_ _1113_ _1204_ tx.tx_busy VGND VGND VPWR VPWR _0139_ sky130_fd_sc_hd__a22o_1
XFILLER_0_59_441 VGND VGND VPWR VPWR sky130_fd_sc_hd__fill_1
XFILLER_0_74_433 VPWR VGND VPWR VGND sky130_ef_sc_hd__decap_12
XFILLER_0_61_116 VGND VGND VPWR VPWR sky130_fd_sc_hd__decap_4
XFILLER_0_46_124 VGND VGND VPWR VPWR sky130_fd_sc_hd__fill_2
X_2639_ clknet_leaf_19_clk _0283_ _0021_ VGND VGND VPWR VPWR rx_fifo.fifo\[6\]\[2\]
+ sky130_fd_sc_hd__edfxtp_1
XFILLER_0_42_363 VGND VGND VPWR VPWR sky130_fd_sc_hd__fill_1
X_2708_ clknet_leaf_2_clk _0382_ net51 VGND VGND VPWR VPWR tx_fifo.fifo\[14\]\[1\]
+ sky130_fd_sc_hd__edfxtp_1
XFILLER_0_77_293 VPWR VGND VPWR VGND sky130_ef_sc_hd__decap_12
XFILLER_0_65_422 VGND VGND VPWR VPWR sky130_fd_sc_hd__fill_1
XFILLER_0_37_113 VGND VGND VPWR VPWR sky130_fd_sc_hd__decap_8
XFILLER_0_52_149 VGND VGND VPWR VPWR sky130_fd_sc_hd__decap_3
XFILLER_0_20_29 VGND VGND VPWR VPWR sky130_fd_sc_hd__fill_2
XTAP_709 VGND VPWR sky130_fd_sc_hd__tapvpwrvgnd_1
XFILLER_0_60_193 VGND VGND VPWR VPWR sky130_fd_sc_hd__decap_3
XFILLER_0_60_182 VGND VGND VPWR VPWR sky130_fd_sc_hd__fill_2
XFILLER_0_45_15 VPWR VGND VPWR VGND sky130_ef_sc_hd__decap_12
Xmax_cap4 _1008_ VGND VGND VPWR VPWR net383 sky130_fd_sc_hd__clkbuf_1
X_2990_ clknet_leaf_13_clk _0372_ net245 VGND VGND VPWR VPWR tx.baud_cnt\[9\] sky130_fd_sc_hd__dfrtp_2
XFILLER_0_71_403 VPWR VGND VPWR VGND sky130_ef_sc_hd__decap_12
X_1941_ net72 _0903_ VGND VGND VPWR VPWR _0467_ sky130_fd_sc_hd__nor2_1
X_1872_ net60 _0891_ VGND VGND VPWR VPWR _0389_ sky130_fd_sc_hd__nor2_1
XFILLER_0_50_7 VGND VGND VPWR VPWR sky130_fd_sc_hd__fill_1
X_1306_ net179 _0547_ VGND VGND VPWR VPWR net16 sky130_fd_sc_hd__nor2_2
X_2286_ net267 net11 net123 VGND VGND VPWR VPWR _0110_ sky130_fd_sc_hd__mux2_1
X_2424_ _0515_ _1090_ net222 VGND VGND VPWR VPWR _1198_ sky130_fd_sc_hd__a21oi_1
X_2355_ net218 _0907_ net58 VGND VGND VPWR VPWR _0012_ sky130_fd_sc_hd__nor3_2
XFILLER_0_19_113 VGND VGND VPWR VPWR sky130_fd_sc_hd__decap_8
XFILLER_0_47_444 VGND VGND VPWR VPWR sky130_fd_sc_hd__decap_4
XFILLER_0_65_241 VGND VGND VPWR VPWR sky130_fd_sc_hd__fill_1
XFILLER_0_57_219 VGND VGND VPWR VPWR sky130_fd_sc_hd__decap_4
XFILLER_0_53_447 VGND VGND VPWR VPWR sky130_fd_sc_hd__fill_1
Xwire132 _0757_ VGND VGND VPWR VPWR net132 sky130_fd_sc_hd__buf_1
Xwire121 net122 VGND VGND VPWR VPWR net121 sky130_fd_sc_hd__clkbuf_2
XFILLER_0_0_205 VGND VGND VPWR VPWR sky130_fd_sc_hd__fill_1
Xwire143 net144 VGND VGND VPWR VPWR net143 sky130_fd_sc_hd__buf_1
XFILLER_0_18_190 VGND VGND VPWR VPWR sky130_fd_sc_hd__decap_6
XTAP_539 VGND VPWR sky130_fd_sc_hd__tapvpwrvgnd_1
XTAP_528 VGND VPWR sky130_fd_sc_hd__tapvpwrvgnd_1
XTAP_517 VGND VPWR sky130_fd_sc_hd__tapvpwrvgnd_1
XTAP_506 VGND VPWR sky130_fd_sc_hd__tapvpwrvgnd_1
X_2140_ _1029_ _1030_ _1031_ _1036_ VGND VGND VPWR VPWR _1037_ sky130_fd_sc_hd__nand4_1
XFILLER_0_0_249 VGND VGND VPWR VPWR sky130_fd_sc_hd__decap_3
X_2071_ _0946_ _0952_ VGND VGND VPWR VPWR _0980_ sky130_fd_sc_hd__nand2_1
XFILLER_0_71_200 VPWR VGND VPWR VGND sky130_ef_sc_hd__decap_12
XFILLER_0_56_241 VGND VGND VPWR VPWR sky130_fd_sc_hd__decap_4
X_2973_ clknet_leaf_8_clk _0175_ net243 VGND VGND VPWR VPWR rx.baud_cnt\[8\] sky130_fd_sc_hd__dfrtp_2
X_1855_ tx_fifo.tail\[1\] net223 VGND VGND VPWR VPWR _0888_ sky130_fd_sc_hd__lpflow_isobufsrc_1
X_1924_ net208 net201 VGND VGND VPWR VPWR _0901_ sky130_fd_sc_hd__nand2_4
X_1786_ net105 net149 VGND VGND VPWR VPWR _0305_ sky130_fd_sc_hd__nor2_1
XFILLER_0_31_119 VGND VGND VPWR VPWR sky130_fd_sc_hd__decap_3
X_2269_ net12 net327 _1132_ VGND VGND VPWR VPWR _0095_ sky130_fd_sc_hd__mux2_1
XFILLER_0_41_3 VPWR VGND VPWR VGND sky130_ef_sc_hd__decap_12
X_2338_ net221 net147 _1164_ VGND VGND VPWR VPWR _0027_ sky130_fd_sc_hd__nor3_1
X_2407_ net155 net90 VGND VGND VPWR VPWR _0237_ sky130_fd_sc_hd__nor2_1
XFILLER_0_1_71 VGND VGND VPWR VPWR sky130_fd_sc_hd__decap_8
XFILLER_0_7_393 VPWR VGND VPWR VGND sky130_ef_sc_hd__decap_12
XFILLER_0_30_141 VPWR VGND VPWR VGND sky130_ef_sc_hd__decap_12
Xhold40 tx.shift_reg\[2\] VGND VGND VPWR VPWR net301 sky130_fd_sc_hd__dlygate4sd3_1
Xhold95 divisor\[3\] VGND VGND VPWR VPWR net356 sky130_fd_sc_hd__dlygate4sd3_1
Xhold73 regs.ier\[0\] VGND VGND VPWR VPWR net334 sky130_fd_sc_hd__dlygate4sd3_1
Xhold51 regs.mcr_reg\[7\] VGND VGND VPWR VPWR net312 sky130_fd_sc_hd__dlygate4sd3_1
Xhold62 rx.sample_cnt\[2\] VGND VGND VPWR VPWR net323 sky130_fd_sc_hd__dlygate4sd3_1
Xhold84 rx.shift_reg\[6\] VGND VGND VPWR VPWR net345 sky130_fd_sc_hd__dlygate4sd3_1
XFILLER_0_53_233 VGND VGND VPWR VPWR sky130_fd_sc_hd__fill_1
XFILLER_0_42_27 VGND VGND VPWR VPWR sky130_fd_sc_hd__fill_1
XFILLER_0_67_57 VPWR VGND VPWR VGND sky130_ef_sc_hd__decap_12
X_1571_ divisor\[3\] net237 _0716_ _0776_ VGND VGND VPWR VPWR _0777_ sky130_fd_sc_hd__a22oi_1
XANTENNA_4 regs.rx_fifo_clear VGND VGND VPWR VPWR sky130_fd_sc_hd__diode_2
X_1640_ rx_fifo.tail\[1\] net233 net126 VGND VGND VPWR VPWR _0840_ sky130_fd_sc_hd__and3_1
XTAP_303 VGND VPWR sky130_fd_sc_hd__tapvpwrvgnd_1
XTAP_314 VGND VPWR sky130_fd_sc_hd__tapvpwrvgnd_1
X_2123_ tx_fifo.fifo\[7\]\[5\] _0996_ net191 tx_fifo.fifo\[8\]\[5\] net386 tx_fifo.fifo\[0\]\[5\]
+ VGND VGND VPWR VPWR _1021_ sky130_fd_sc_hd__a222oi_1
XTAP_369 VGND VPWR sky130_fd_sc_hd__tapvpwrvgnd_1
XTAP_358 VGND VPWR sky130_fd_sc_hd__tapvpwrvgnd_1
XTAP_347 VGND VPWR sky130_fd_sc_hd__tapvpwrvgnd_1
XTAP_336 VGND VPWR sky130_fd_sc_hd__tapvpwrvgnd_1
XTAP_325 VGND VPWR sky130_fd_sc_hd__tapvpwrvgnd_1
XFILLER_0_29_241 VGND VGND VPWR VPWR sky130_fd_sc_hd__fill_1
XFILLER_0_8_113 VGND VGND VPWR VPWR sky130_fd_sc_hd__fill_1
X_2054_ net351 net347 _0967_ VGND VGND VPWR VPWR _0046_ sky130_fd_sc_hd__mux2_1
XFILLER_0_16_83 VGND VGND VPWR VPWR sky130_fd_sc_hd__fill_1
X_2887_ clknet_leaf_6_clk _0082_ net242 VGND VGND VPWR VPWR divisor\[11\] sky130_fd_sc_hd__dfrtp_4
X_2956_ clknet_leaf_16_clk _0157_ net248 VGND VGND VPWR VPWR regs.rx_fifo_clear sky130_fd_sc_hd__dfrtp_1
XFILLER_0_32_82 VGND VGND VPWR VPWR sky130_fd_sc_hd__fill_2
X_1838_ tx_fifo.tail\[1\] net223 net76 VGND VGND VPWR VPWR _0878_ sky130_fd_sc_hd__and3_1
X_1907_ _0892_ net203 VGND VGND VPWR VPWR _0898_ sky130_fd_sc_hd__nand2_4
XFILLER_0_17_447 VGND VGND VPWR VPWR sky130_fd_sc_hd__fill_1
XFILLER_0_17_458 VGND VGND VPWR VPWR sky130_fd_sc_hd__decap_4
X_1769_ net117 net150 VGND VGND VPWR VPWR _0300_ sky130_fd_sc_hd__nor2_1
XFILLER_0_12_141 VGND VGND VPWR VPWR sky130_fd_sc_hd__decap_4
XFILLER_0_75_391 VGND VGND VPWR VPWR sky130_fd_sc_hd__fill_1
Xoutput30 net30 VGND VGND VPWR VPWR rdata[6] sky130_fd_sc_hd__clkbuf_4
XFILLER_0_73_317 VGND VGND VPWR VPWR sky130_fd_sc_hd__decap_8
XFILLER_0_41_225 VGND VGND VPWR VPWR sky130_fd_sc_hd__decap_8
X_2672_ clknet_leaf_38_clk _0261_ net95 VGND VGND VPWR VPWR rx_fifo.fifo\[8\]\[2\]
+ sky130_fd_sc_hd__edfxtp_1
XFILLER_0_26_299 VGND VGND VPWR VPWR sky130_fd_sc_hd__decap_8
XFILLER_0_26_277 VGND VGND VPWR VPWR sky130_fd_sc_hd__decap_4
X_2810_ clknet_leaf_39_clk _0444_ net39 VGND VGND VPWR VPWR tx_fifo.fifo\[7\]\[7\]
+ sky130_fd_sc_hd__edfxtp_1
X_2741_ clknet_leaf_1_clk _0479_ _0011_ VGND VGND VPWR VPWR tx_fifo.fifo\[2\]\[2\]
+ sky130_fd_sc_hd__edfxtp_1
X_1554_ _0753_ _0755_ _0759_ _0760_ VGND VGND VPWR VPWR _0761_ sky130_fd_sc_hd__nand4_1
X_1485_ rx.baud_cnt\[8\] _0655_ net360 VGND VGND VPWR VPWR _0704_ sky130_fd_sc_hd__a21oi_1
X_1623_ net18 net238 _0824_ net239 _0734_ data_bits\[0\] VGND VGND VPWR VPWR _0825_
+ sky130_fd_sc_hd__a222oi_1
XTAP_166 VGND VPWR sky130_fd_sc_hd__tapvpwrvgnd_1
.ends
